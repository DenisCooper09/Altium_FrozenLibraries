*  HA-5101
*  COPYRIGHT (C) 1991 HARRIS CORPORATION
*  ALL RIGHTS RESERVED
*
* HA-5101 MACRO MODEL
*
* D.L. Youngblood
* Rev:  8/8/91
*
* Connections:
*               Non-Inverting Input
*               |  Inverting Input
*               |  |  Positive Power Supply
*               |  |  |  Negative Power Supply
*               |  |  |  |   Output
*               |  |  |  |   |
.SUBCKT HA5101  6  7  9  10  8
.MODEL DP D  IS=1E-14  N=2.8162E+00
.MODEL DN D  IS=8.9762E-15 N=2.8162E+00
.MODEL DV D  IS=3.0966E-14  N=.2
.MODEL D1 D  IS=1E-14  N=1
.MODEL D2 D  IS=1E-14  N=1.0841E+00
*
* Input Stage
*
VP 6 12 0
DP 12 1 DP
*
* The value of source "VIO" represents offset voltage
* and may be changed to simulate worst case if desired
*
VIO 7 13 1.5987E-04
*
DN 13 1 DN
FA 7 0 VIO 3.5294E-01
I1 1 0 1.6130E-07
C1 1 0 8.8812E-16             IC=-1.1545E+00
FP 4 0 VP  1.4025E+03
FN 0 4 VIO  1.5625E+03
GPP 0 4 9 14 8.0498E-10
GPN 0 4 15 10 3.8511E-09
RT 4 0 1.0
VPP 14 0 1.50E+01
RPP 14 0 1K
VPN 0 15 1.50E+01
RPN 0 15 1K
GC 0 4 1 0 1.6475E-08
IRX 0 4 -2.667E-08
*
* General Poles
*
EP1 16 0 4 0 1.0
RP1 16 17 9.0176E+01
CP1 17 0 1.0E-10
EP2 18 0 17 0 1.0
RP2 18 19 1.2731E+01
CP2 19 0 1.0E-10
EP3 20 0 19 0 1.0
RP3 20 21 1.2731E+01
CP3 21 0 1.0E-10
EP4 22 0 21 0 1.0
RP4 22 23 1.1385E+01
CP4 23 0 1.0E-10
EP5 24 0 23 0 1.0
RP5 24 25 6.4181E+00
CP5 25 0 1.0E-10
*
* General Zeros
*
GZ1 0 30 25 0 2.7671E-03
VZ01 30 31 0.0
HZ1 31 32 VZ01   3.6139E+02
LZ1 32 0 1.0E-6
GZ2 0 33 30 0 -1.0055E-03
VZ02 33 34 0.0
HZ2 34 35 VZ02   -9.9455E+02
LZ2 35 0 1.0E-6
GZ3 0 36 33 0 -6.9434E-04
VZ03 36 37 0.0
HZ3 37 38 VZ03   -1.4402E+03
LZ3 38 0 1.0E-6
*
* Complex Zero
*
EZZ 39 0 36 0 1.0
VZZ 39 40 0.0
CZZ 40 0 1.0E-12
RZZ 40 0 1.0E+7
FCZ 0 41 VZZ    1.0
RCZ 41 42 3.8073E+03
LCZ 42 43 7.0771E-06
CCZ 43 0 1.0E-12
RXZ 43 0 1.0E+7
*
* Gain / Output Stage
*
G2 0 2 41 0 1.0
R2 2 0 2.7509E+06
CC 2 3 2.20E-11
GOL 3 0 2 0 3.9807E-2
RD 3 0 5.9935E+02
DH 3 5 DV
DL 50 3 DV
VH 9 5 -1.187E+00
VL 50 10 1.333E+00
IH 9 0 3.50E-03
IL 0 10 3.50E-03
D1 3 53 D1
D2 53 3 D2
*EX1 53 0 POLY  2  3 0 3 8 0  1  -2.7887E-01
BEX1 53 0 V=1*v(3,0)-2.7887E-01*v(3,8)
RO 54 8 4.2754E+01
VIS 3 54 0
FI 0 55 VIS  1
DIP 55 56 DV
DIN 58 57 DV
VIP 56 58 0
VIN 57 55 0
RI 58 0 1
FIP 9 0 VIP  1
FIN 0 10 VIN  1
.ENDS HA5101
