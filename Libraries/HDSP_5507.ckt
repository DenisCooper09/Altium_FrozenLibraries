*
* Diode Model Produced by Altium Ltd
* Date:  6-Apr-2004
*
* Manufacturer: Agilent
* Component Name: HDSP-5507
*
* Parameters derived from information available in data sheet.
*
*                 cathode-c
*                 |  anode-c, d
*                 |  |  cathode-b
*                 |  |  |  anode-a, b, DP
*                 |  |  |  |  cathode-DP
*                 |  |  |  |  |  cathode-a
*                 |  |  |  |  |  |  anode-a, b, DP
*                 |  |  |  |  |  |  |  anode-c, d
*                 |  |  |  |  |  |  |  |  cathode-d
*                 |  |  |  |  |  |  |  |  |
.SUBCKT HDSP_5507 1  2  3  4  5  6  7  8  9

DA1   4  6 dHDSP_5507
DB1   4  3 dHDSP_5507
DDP1  4  5 dHDSP_5507

DA2   7  6 dHDSP_5507
DB2   7  3 dHDSP_5507
DDP2  7  5 dHDSP_5507

DC1   2  1 dHDSP_5507
DD1   2  9 dHDSP_5507

DC2   8  1 dHDSP_5507
DD2   8  9 dHDSP_5507

.MODEL dHDSP_5507 D
+ (
+     IS = 3.78006861E-14
+      N = 2.44553183
+     RS = 19.51958310
+     BV = 30
+    IBV = 100u
+ )

.ENDS HDSP_5507
