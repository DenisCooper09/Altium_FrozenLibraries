.SUBCKT TC4405_I2D_A 1 2 3 4 5
*                    | | | | |
*                    | | | | Output 2
*                    | | | Negative Supply
*                    | | Positive Supply
*                    | Output 1
*                    Input
*
********************************************************************************
* Software License Agreement                                                   *
*                                                                              *
* The software supplied herewith by Microchip Technology Incorporated (the     *
* 'Company') is intended and supplied to you, the Company's customer, for use  *
* soley and exclusively on Microchip products.                                 *
*                                                                              *
* The software is owned by the Company and/or its supplier, and is protected   *
* under applicable copyright laws. All rights are reserved. Any use in         *
* violation of the foregoing restrictions may subject the user to criminal     *
* sanctions under applicable laws, as well as to civil liability for the       *
* breach of the terms and conditions of this license.                          *
*                                                                              *
* THIS SOFTWARE IS PROVIDED IN AN 'AS IS' CONDITION. NO WARRANTIES, WHETHER    *
* EXPRESS, IMPLIED OR STATUTORY, INCLUDING, BUT NOT LIMITED TO, IMPLIED        *
* WARRANTIES OF MERCHANTABILITY AND FITNESS FOR A PARTICULAR PURPOSE APPLY TO  *
* THIS SOFTWARE. THE COMPANY SHALL NOT, IN ANY CIRCUMSTANCES, BE LIABLE FOR    *
* SPECIAL, INCIDENTAL OR CONSEQUENTIAL DAMAGES, FOR ANY REASON WHATSOEVER.     *
********************************************************************************
*
* The following MOSFET drivers are covered by this model:
*      1.5A Inverting Dual Open Drain Driver - TC4404
*
* Polarity: Inverting
*
* Date of model creation: 8/26/2008
* Level of Model Creator: G
*
* Revision History:
*      10/29/08 RAW Initial model creation
*
*
*
*
* Recommendations:
*      Use PSPICE (or SPICE 2G6; other simulators may require translation)
*      For a quick, effective design, use a combination of: data sheet
*            specs, bench testing, and simulations with this macromodel
*      For high impedance circuits, set GMIN=100F in the .OPTIONS statement
*
* Supported:
*      Typical performance for temperature range (-40 to 125) degrees Celsius
*      DC, AC, Transient, and Noise analyses.
*      Most specs, including: propgation delays, rise times, fall times, max sink/source current,
*            input thresholds, voltage ranges, supply current, ... , etc.
*      Temperature effects for Ibias, Iquiescent, output current, output
*            resistance,....,etc.
*
* Not Supported:
*      Some Variation in specs vs. Power Supply Voltage
*      Vos distribution, Ib distribution for Monte Carlo
*      Some Temperature analysis
*      Process variation
*      Behavior outside normal operating region
*
* Known Discrepancies in Model vs. Datasheet:
*
*
*
* Input Impedance/Clamp
* Input Impedance/Clamp
R1  4    1    100MEG
C1  4    1    12.0P
G3  3    1    TABLE { V(3, 1) } ((-770M,-1.00)(-700M,-10.0M)(-630M,-1.00N)(0,0)(20.0,1.00N))
G4  1    4    TABLE { V(1, 4) } ((-5.94,-1.00)(-5.4,-10.0M)(-4.86,-1.00N)(0,0)(20.0,1.00N))
* Threshold
G11 0    30   TABLE { V(1, 11) } ( (-1m,10n)(0,0)(0.78,-.1)(1.25,-1)(2,-1) )
G12 0    30   TABLE {V(1,12)} ( (-2,1)(-1.2,1)(-0.6,.1)(0,0)(1,-10n))
G21 0    11   TABLE { V(3, 4) } ((0,1.35)(4.00,1.35)(6.00,1.5)(10.0,1.48)(13.0,1.49)(16.0,1.5))
G22 0    12   TABLE { V(3, 4) } ((0,1.35)(4.00,1.16)(6.00,1.25)(10.0,1.24)(13.0,1.24)(16.0,1.25))
R21 0    11   1 TC=504U,2.33U; *Changed syntax
R22 0    12   1 TC=231U,-103N; *Changed syntax
C30 30   0    1n
* HL Circuit
G31 0    31   TABLE { V(3, 4) } ((0,90.0)(5.00,25.8)(6.00,25.0)(8.00,25.3)(14.0,26.0)(18.0,22.9))
R31 31   0    1 TC=2.37M,-2.32U; *Changed syntax
G33 0    30   TABLE { V(31, 30) } ( (-1M,-10)(0,0)(1,10N) )
S31 31   30 31 30 SS31
* LH Circuit
G32 32   0    TABLE { V(3, 4) } ((0,54.0)(5.00,5.8)(6.00,5.5)(8.00,5.4)(14.0,5.8)(18.0,6.8))
R32 0    32   1 TC=2.49M,-836N; *Changed syntax
G34 30   0    TABLE { V(30, 32) } ( (-1M,-10)(0,0)(1,10N) )
R30 32   30   1MEG
* DRIV
G51 0    50   TABLE { V(0, 30) } ( (-5,-1U)(-3,-1U)(0,0)(6,1.0)(18,1.0) )
G52 50   0    TABLE { V(30, 0) } ( (-5,-1U)(-3,-1U)(0,0)(6,1.1)(18,1.1) )
R53 0    50   1
G50 51   0   VALUE {V(50,0)*250M/(-700M+18.0/(V(3,4) + 1M))}
R51 51    0   1
G53  3    0   TABLE {V(51,0)} ((-100,100)(0,0)(1,1n))
G54  0    4   TABLE {V(0,51)} ((-100,100)(0,0)(1,1n))
R60A 0   60A   100MEG
R60B 0   60B   100MEG
H67A 0    69A   V67A 1
V67A 60A   59A   0V
C60 561  51   250P
R59A 59A   2    8.19
L59A 59A   2    10.0N
H67B 0    69B   V67B 1
V67B 60B   59B   0V
R59B 59B   5    8.19
L59B 59B   5    10.0N
* Shoot-through adjustment
VC60 56 0 0V
RC60 56 561 1m
H60 58 0 VC60 56
G60P 0 3 TABLE { V(58, 0) } ((-1,-1u)(0,0)(25,10.0M)(40,0))
G60N 4 0 TABLE { V(0, 58) } ((-1,-1u)(0,0)(25,10.0M)(40,0))
* Source Output
E67 67   0    TABLE { V(69A, 0) } ( (-1.5,-1.5)(0,0)(1,2.00) )
G63 0    63   POLY(1) 3 4 22.7 -1.81 52.1M
R63 0    63   1 TC=4.21M,13.4U; *Changed syntax
E61 61   65   VALUE {V(67,0)*V(63,0)}
V63 65   3    100U
G61 61   60A   TABLE { V(61, 60A) } (-20.0M,-150)(-15.0M,-75.0)(-10.0M,-15.0)(0,0)(10,1N))
G59 0    60A VALUE { if(V(51, 0)<0,-V(51, 0),0) }
* Sink Output
E68 68   0    TABLE { V(69B, 0) }  ( (-1,-2.00)(0,0)(1.7,1.7) )
G64 0    64   POLY(1) 3 4 23.2 -1.64 39.5M
R64 0    64   1 TC=4.05M,11u; *Changed syntax
E62 62   66   VALUE {V(68,0)*V(64,0)}
V64 66   4    100U
G62 60B  62   TABLE { V(60B, 62) } (-20.0M,-170)(-15.0M,-85.0)(-10.0M,-17.0)(0,0)(10,1N))
G70 0    60B VALUE { if(V(51, 0)>0,-V(51, 0),0) }
* Bias Current
G55 0    55   TABLE { V(3, 4) } ((0,0)(4.5,485U)(10.0,580u)(14.0,925u)(18.0,1.385M))
G56 3    4    55 0 1
R55 55   0    1 TC=-1.39M,186N; *Changed syntax
G57 0    57   TABLE { V(3, 4) } ((0,0)(4.5,65U)(10.0,70U)(14.0,75U)(18.0,115U))
G58 3    4    57 0 1
R57 57   0    1 TC=-1.39M,186N; *Changed syntax
S59 55   0    1 0 SS59
* Models
.MODEL SS59 VSWITCH Roff=1m Ron=100Meg Voff=1.2V Von=1.5V
.MODEL SS31 VSWITCH Roff=100MEG Ron=800 Voff=0.2V Von=0.1V
.ENDS TC4405_I2D_A
