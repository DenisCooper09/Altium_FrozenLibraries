*
* Common Terminal Circuits
*ResPack_15
*
.SUBCKT EXBM16P 1 2 3 4 5 6 7 8 9 10 11 12 13 14 15 16 PARAMS: Res1=1k
R1 1 16 {Res1}
R2 2 16 {Res1}
R3 3 16 {Res1}
R4 4 16 {Res1}
R5 5 16 {Res1}
R6 6 16 {Res1}
R7 7 16 {Res1}
R8 8 16 {Res1}
R9 9 16 {Res1}
R10 10 16 {Res1}
R11 11 16 {Res1}
R12 12 16 {Res1}
R13 13 16 {Res1}
R14 14 16 {Res1}
R15 15 16 {Res1}
.ENDS EXBM16P
