*
* Diode Model Produced by Altium Ltd
* Date:  7-Apr-2004
*
* Manufacturer: Agilent
* Component Name: 5082-7626
*
* Parameters derived from information available in data sheet.
*
*                 anode-d
*                 |  cathode-d
*                 |  |  cathode-c
*                 |  |  |  cathode-e
*                 |  |  |  |  anode-e
*                 |  |  |  |  |  anode-c
*                 |  |  |  |  |  |  anode-DP
*                 |  |  |  |  |  |  |  cathode-DP
*                 |  |  |  |  |  |  |  |  cathode-b
*                 |  |  |  |  |  |  |  |  |  cathode-a
*                 |  |  |  |  |  |  |  |  |  |  anode-a
*                 |  |  |  |  |  |  |  |  |  |  |  anode-b
*                 |  |  |  |  |  |  |  |  |  |  |  |
.SUBCKT 5082_7626 1  3  4  5  6  7  8  10 11 12 13 14

DA  13 12 d5082_7626
DB  14 11 d5082_7626
DC   7  4 d5082_7626
DD   1  3 d5082_7626
DE   6  5 d5082_7626
DDP  8 10 d5082_7626

.MODEL d5082_7626 D
+ (
+     IS = 6.04055825E-18
+      N = 1.90788337
+     RS = 23.52447762
+     BV = 40
+    IBV = 100u
+ )

.ENDS 5082_7626
