*MBR4045PT MCE 3/30/98
*Ref: IR Power Semiconductors Product Digest '94
*MCE 45V 40A 3us pkg:TO-247 1,2,3
.SUBCKT MBR4045PT 1 2 3
D1 1 2 DA
D2 3 2 DA
.MODEL DA D (IS=56.8N RS=1.05M N=1.7 BV=45 IBV=70M
+ CJO=1.65N VJ=0.75 M=0.333 TT=4.32U EG=.69 XTI=2)
.ENDS MBR4045PT
