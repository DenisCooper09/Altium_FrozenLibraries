*
* Diode Model Produced by Altium Ltd
* Date:  7-Apr-2004
*
* Manufacturer: Agilent
* Component Name: HDSP-3906
*
* Parameters derived from information available in data sheet.
*
*                 cathode-a
*                 |  anode-d
*                 |  |  cathode-d
*                 |  |  |  cathode-c
*                 |  |  |  |  cathode-e
*                 |  |  |  |  |  anode-e
*                 |  |  |  |  |  |  cathode-DP
*                 |  |  |  |  |  |  |  anode-DP
*                 |  |  |  |  |  |  |  |  cathode-DP
*                 |  |  |  |  |  |  |  |  |  cathode-b
*                 |  |  |  |  |  |  |  |  |  |  anode-b
*                 |  |  |  |  |  |  |  |  |  |  |  anode-c
*                 |  |  |  |  |  |  |  |  |  |  |  |  anode-a
*                 |  |  |  |  |  |  |  |  |  |  |  |  |  cathode-a
*                 |  |  |  |  |  |  |  |  |  |  |  |  |  |
.SUBCKT HDSP_3906 2  3  4  5  6  7  8  10 11 12 13 14 15 17

DA1  15  2 dHDSP_3906
DA2  15 17 dHDSP_3906
DB   13 12 dHDSP_3906
DC   14  5 dHDSP_3906
DD    3  4 dHDSP_3906
DE    7  6 dHDSP_3906
DDP1 10  8 dHDSP_3906
DDP2 10 11 dHDSP_3906

.MODEL dHDSP_3906 D
+ (
+     IS = 1E-13
+      N = 2.7
+     RS = 6.22331865
+     BV = 2.25
+    IBV = 100u
+ )

.ENDS HDSP_3906
