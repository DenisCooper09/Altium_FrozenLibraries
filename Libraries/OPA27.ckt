* OPA27 OPERATIONAL AMPLIFIER "MACROMODEL" SUBCIRCUIT

* CREATED USING PARTS RELEASE 4.03 ON 09/20/90 AT 16:00

* REV.A

*  ------------------------------------------------------------------------

* |  NOTICE: THE INFORMATION PROVIDED HEREIN IS BELIEVED TO BE RELIABLE;   |

* |  HOWEVER; BURR-BROWN ASSUMES NO RESPONSIBILITY FOR INACCURACIES OR     |

* |  OMISSIONS.  BURR-BROWN ASSUMES NO RESPONSIBILITY FOR THE USE OF THIS  |

* |  INFORMATION, AND ALL USE OF SUCH INFORMATION SHALL BE ENTIRELY AT     |

* |  THE USER'S OWN RISK.  NO PATENT RIGHTS OR LICENSES TO ANY OF THE      |

* |  CIRCUITS DESCRIBED HEREIN ARE IMPLIED OR GRANTED TO ANY THIRD PARTY.  |

* |  BURR-BROWN DOES NOT AUTHORIZE OR WARRANT ANY BURR-BROWN PRODUCT FOR   |

* |  USE IN LIFE-SUPPORT DEVICES AND/OR SYSTEMS.                           |

*  ------------------------------------------------------------------------

*

* CONNECTIONS:   NON-INVERTING INPUT

*                | INVERTING INPUT

*                | | POSITIVE POWER SUPPLY

*                | | | NEGATIVE POWER SUPPLY

*                | | | | OUTPUT

*                | | | | |

.SUBCKT OPA27    1 2 3 4 5

*

C1   11 12 20.79E-12

C2    6  7 114.3E-12

CEE  10 99 5.713E-12

DC    5 53 DX

DE   54  5 DX

DLP  90 91 DX

DLN  92 90 DX

DP    4  3 DX

EGND 99  0 POLY(2) (3,0) (4,0) 0 .5 .5

FB    7 99 POLY(5) VB VC VE VLP VLN 0 10.95E6 -10E6 10E6 10E6 -10E6

GA    6  0 11 12 4.638E-3

GCM   0  6 10 99 2.608E-9

IEE  10  4 DC 240.0E-6

HLIM 90  0 VLIM 1K

Q1   11  2 13 QX

Q2   12  1 14 QX

R2    6  9 100.0E3

RC1   3 11 215.6

RC2   3 12 215.6

RE1  13 10 5.395E-3

RE2  14 10 5.395E-3

REE  10 99 833.5E3

RO1   8  5 35

RO2   7 99 35

RP    3  4 10.87E3

VB    9  0 DC 0

VC    3 53 DC 1.200

VE   54  4 DC 1.200

VLIM  7  8 DC 0

VLP  91  0 DC 25

VLN   0 92 DC 25

.MODEL DX D(IS=800.0E-18)

.MODEL QX NPN(IS=800.0E-18 BF=7.998E3)

.ENDS


