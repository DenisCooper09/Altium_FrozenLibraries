*
*ZETEX  ZXMD63N02X Mosfet Spice Subcircuit   Last revision 3/7/00
*
* BC 5/1/2004: converted from pspice to spice
*
.SUBCKT ZXMD63N02X 3 4 5
*               D G S
M1 3 2 5 5 M63N02
RG 4 2 18
RL 3 5 1E9
C1 2 5 700E-12
C2 3 2 50E-12
D1 5 3 D63N02
*
.MODEL M63N02 NMOS VTO=1.40 RS=0.04 RD=0.02 KP=15
+CBD=600E-12 LAMBDA=8.7E-3

* .MODEL D63N02 D IS=4E-12 N=1.04 IKF=82E-3 RS=105E-3
.MODEL D63N02 D (IS=1.0080E-11 N=1.1161 RS=0.1255)

.ENDS ZXMD63N02X
*
*$
