*   ////////////// MAX4105 MACROMODEL //////////////////
* * MAX4105        Single Op Amp (Minimum Stable Gain  of 5)
*
*   ====>      REFER TO MAX4104 DATA SHEET       <====
*
* connections:          non-inverting input
*                       |       inverting input
*                       |       |       positive power-supply
*                       |       |       |       negative power-supply
*                       |       |       |       |       output
*                       |       |       |       |       |
* OUTPUT CONNECTS:      1       2       99      50      97
*
.SUBCKT MAX4105 1 2 99 50 97
****************INPUT STAGE**********************
Isy 99 50 -19MA
*fixes supply current
IOS 2 1 .5ua
IB1 0 2 30ua
IB2 0 1 30ua
I1 4 50 1MA
GIN 2 1 2 1 50E-9
*CIN 1 2 .5PF
R1 5 99 52
*3.7
R2 6  99 52
VOS 1 9 0V
*EOS 1 9 POLY(1) 98 30 0 1
*BEOS 1 9 V=1*v(98,30)
*               ^       OFFSET VOLTAGE
Q1 5 2 400 QX
Q2 6 9 401 QX
*Csecondp 5 6 20p
*** ************
RD1 400 4 52
RD2 401 4 52
Dsub 50 99 DX
****OUTPUT VOLTAGE LIMITING****
V2 99 11 2.03
D1 12 11 DX
D2 10 12 DX
V3 10 50 1.93
****LEVEL TRANSLATION ****
EH 99 98 99 50 0.5
****GAIN, 1ST POLE****
*G3 98 12 5 6 0.0352
G3 98 12 5 6 0.0102
R4 12 98 174K
*40K
C3 98 12 .036E-11
*
**************FREQUENCY SHAPING STAGES********
*
****POLE STAGE****
G5 98 15 12 98 1E-3
*D13 50 15 DX
R5 98 15 1E3
*c5 98 15 .05E-12
*
*******************OUTPUT STAGE****************
F6 99 50 VA7 1
F5 99 38 VA8 1
D9 40 38 DX
D10 38 99 DX
VA7 99 40 0
****************
G12 98 32 15 98 1E-3
*************  ******************************
R15 98 32 1E3
D3 32 36 DX
D4 37 32 DX
V5 35 37 0v
V4 36 35 0V
R16 34 35 8
E1 99 33 99 32 1
VA8 33 34 0V
L 35 97 200P
*
***** MODELS USED ******
.MODEL DX D(IS=1E-15)
.MODEL QX NPN(BF=15e3)
.ends
