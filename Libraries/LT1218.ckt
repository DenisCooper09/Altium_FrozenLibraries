*/////////////////////////////////////////////////////////////////////////
* LT1218  Precision Rail-to-Rail Input and Output Operational Amplifier //
*/////////////////////////////////////////////////////////////////////////
*
* connections:    non-inverting input
*                 |   inverting input
*                 |   |   positive power supply
*                 |   |   |   negative power supply
*                 |   |   |   |   output
*                 |   |   |   |   |
*                 |   |   |   |   |
.SUBCKT LT1218    3   2   7   4   6

X_LT1218 3 2 7 4 6 LT1366
.SUBCKT LT1366     3 2 7 4 6

*Q3 18 10 14 [4] PL1 1
*Q4 19 11 14 [4] PL1 1.006
*Q3C 19 10 10 [4] PL1 2
*Q4C 18 11 11 [4] PL1 2
*Q5 16 15 14 [4] PL1 1
*Q2 13 10 17 [4] NL1 1
*Q1 12 11 17 [4] NL1 1.006
*jg, 29/6/2000: corrected syntax errors.

Q3 18 10 14 4 PL1 1
Q4 19 11 14 4 PL1 1.006
Q3C 19 10 10 4 PL1 2
Q4C 18 11 11 4 PL1 2
Q5 16 15 14 4 PL1 1
Q2 13 10 17 4 NL1 1
Q1 12 11 17 4 NL1 1.006

RINP 10 3 500
RINN 11 2 500
R3 4 18 5K
R1 12 7 5K
RCMP 14 7 12MEG
R4 4 19 5K
RI 21 24 8K
R2 13 7 5K
ROUT1 22 6 31.2
ROUT2 22 0 80K
RCMN 4 17 12MEG
RO1 0 20 25MEG
RPS1 4 20 1600MEG
RPS2 20 7 1600MEG

C1 12 13 8.6PF
C2 18 19 8.6PF
CI 24 6 12PF
CCMP 14 7 1.6PF
CCMN 4 17 1.6PF
CF 20 6 71.5PF
CPS2 20 7 0.1PF
CPS1 4 20 0.1PF

VESAT 26 4 0.814
VCSAT 7 25 0.814
VSENSE 16 4 0

F1 17 4 VSENSE 1
VLS 7 15 1.4
GN1 7 20 13 12 400U
GP1 20 4 19 18 400U
GOUT 0 22 0 24 21E-3

I1 7 14 5U
IOS 3 2 1NA
IQ 7 4 345U

E1 21 0 20 0 1.31
EOUT 23 0 6 0 1

DI2 11 7 DM1
DI1 10 7 DM1
DC1 20 0 DMX
DO1 6 25 DM1
DO2 26 6 DM1
DL1 23 22 DMX
DL2 22 23 DMX
DC2 0 20 DMX
DSUB 4 7 DM2
.ENDS LT1366

*.MODEL PL1 LPNP
*+ IS=570E-18
*+ BF=263      BR=0.17  VAF=115
*+ TF=42E-9    TR=7.7E-6
*+ CJE=0.115PF VJE=0.62 MJE=0.44 FC=0.5
*+ CJC=0.948PF VJC=0.62 MJC=0.44
*+ CJS=2.695PF VJS=0.60 MJS=0.36

.MODEL PL1 PNP  (IS=570E-18
+ BF=263      BR=0.17  VAF=115
+ TF=42E-9    TR=7.7E-6
+ CJE=0.115PF VJE=0.62 MJE=0.44 FC=0.5
+ CJC=0.948PF VJC=0.62 MJC=0.44
+ CJS=2.695PF VJS=0.60 MJS=0.36)

*.MODEL NL1 NPN
*+ IS=1.33E-15
*+ BF=240      BR=0.22  VAF=80
*+ TF=42E-9    TR=7.7E-6
*+ CJE=0.078PF VJE=0.62 MJE=0.44 FC=0.5
*+ CJC=0.749PF VJC=0.62 MJC=0.44
*+ CJS=0.000PF VJS=0.60 MJS=0.36
*jg, 29/6/2000: corrected model syntax errors.

.MODEL NL1 NPN  (IS=1.33E-15
+ BF=240      BR=0.22  VAF=80
+ TF=42E-9    TR=7.7E-6
+ CJE=0.078PF VJE=0.62 MJE=0.44 FC=0.5
+ CJC=0.749PF VJC=0.62 MJC=0.44
+ CJS=0.000PF VJS=0.60 MJS=0.36)

.MODEL DM1 D (IS=8E-16)
.MODEL DMX D (IS=3.4E-24)
.MODEL DM2 D (IS=8E-16 BV=39)

.ENDS LT1218

.END
