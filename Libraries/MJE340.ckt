*MJE340 MCE Power Transistor Subcircuit 1/30/96
*    TERMINALS:  C B E
*Si 20.8W 300V 500mA pkg:TO-220 2,3,1
.SUBCKT MJE340  1 2 3
Q1 1 2 3  PWR .67
Q2 1 4 3  PWR .33
RBS  2 4  6.5
.MODEL PWR NPN (IS=36.8F NF=1 BF=260 VAF=311 IKF=.166 ISE=12.3P NE=2
+ BR=4 NR=1 VAR=12 IKR=.25 RE=.663 RB=2.65 RC=.265 XTB=1.5
+ CJE=18.8P VJE=.6 MJE=.3 CJC=12.2P VJC=.22 MJC=.2 TF=7.65N TR=294N)
.ENDS MJE340
