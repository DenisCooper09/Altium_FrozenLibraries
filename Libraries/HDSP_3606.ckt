*
* Diode Model Produced by Altium Ltd
* Date:  7-Apr-2004
*
* Manufacturer: Agilent
* Component Name: HDSP-3606
*
* Parameters derived from information available in data sheet.
*
*                 anode-d
*                 |  cathode-d
*                 |  |  cathode-c
*                 |  |  |  cathode-e
*                 |  |  |  |  anode-e
*                 |  |  |  |  |  anode-c
*                 |  |  |  |  |  |  anode-DP
*                 |  |  |  |  |  |  |  cathode-DP
*                 |  |  |  |  |  |  |  |  cathode-b
*                 |  |  |  |  |  |  |  |  |  cathode-a
*                 |  |  |  |  |  |  |  |  |  |  anode-a
*                 |  |  |  |  |  |  |  |  |  |  |  anode-b
*                 |  |  |  |  |  |  |  |  |  |  |  |
.SUBCKT HDSP_3606 1  3  4  5  6  7  8  10 11 12 13 14

DA  13 12 dHDSP_3606
DB  14 11 dHDSP_3606
DC   7  4 dHDSP_3606
DD   1  3 dHDSP_3606
DE   6  5 dHDSP_3606
DDP  8 10 dHDSP_3606

.MODEL dHDSP_3606 D
+ (
+     IS = 1.61114016E-27
+      N = 1.30291189
+     RS = 12.83456794
+     BV = 50
+    IBV = 100u
+ )

.ENDS HDSP_3606
