.SUBCKT BFG21W  1 2 3
Llf1	2 5 281E-12
Lbw1	5 8 720.9E-12
Llf2	1 4 280E-12
Lbw2	4 7 571E-12
Llf3	3 6 69.14E-12
Lbw3	6 9 51.5E-12
Ccb	4 5 2.0E-15
Cbe	5 6 80.0E-15
Cce	4 6 80.0E-15
Cbpb	8 12 330E-15
Cbpc	7 13 347E-15
Cmet	7 9 1.7E-12
Rsb1	12 11 249.2
Rsb2	13 11 464.4
Rmut	9 11 100
R4	9 10 1e-3
Dcsb	11 7 Diode
Q1 7 8 9 10 XB21

.MODEL XB21 NPN
+(
+ IS = 383.5E-18
+ BF = 92.00
+ NF = 1.000
+ VAF = 35.00
+ IKF = 2.8
+ ISE = 900.5E-15
+ NE = 2.262
+ BR = 8.900
+ NR = 1.009
+ VAR = 2.250
+ IKR = 650.7E-3
+ ISC = 2.503E-15
+ NC = 1.209
+ RB = 1.492
+ IRB = 0
+ RBM = 320.2E-3
+ RE = 342.9E-3
+ RC = 800.0E-3
+ CJE = 3.026E-12
+ VJE = 0.9
+ MJE = 286.1E-3
+ CJC = 1.041E-12
+ VJC = 696.4E-3
+ MJC = 308.0E-3
+ CJS = 1.844E-12
+ VJS = 423.7E-3
+ MJS = 260.6E-3
+ XCJC = 0.5
+ TR = 150.0E-12
+ TF = 5.05E-12
+ XTF = 74.00
+ VTF = 800E-3
+ ITF = 6.500
+ PTF = 0
+ FC = 0.875
+ EG = 1.11
+ XTI = 4.300
+ XTB = 500E-3
+)

.MODEL Diode D
+(
+IS=499E-15
+RS=3.5
+N=1.189
+)
.ENDS
