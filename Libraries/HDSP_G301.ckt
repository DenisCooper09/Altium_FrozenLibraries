*
* Diode Model Produced by Altium Ltd
* Date:  10-Mar-2004
*
* Manufacturer: Agilent
* Component Name: HDSP-G301
*
* Parameters derived from information available in data sheet.
*
*                 e-cathode-1
*                 |  d-cathode-1
*                 |  |  c-cathode-1
*                 |  |  |  dp-cathode-1
*                 |  |  |  |  e-cathode-2
*                 |  |  |  |  |  d-cathode-2
*                 |  |  |  |  |  |  g-cathode-2
*                 |  |  |  |  |  |  |  c-cathode-2
*                 |  |  |  |  |  |  |  |  cp-cathode-2
*                 |  |  |  |  |  |  |  |  |  b-cathode-2
*                 |  |  |  |  |  |  |  |  |  |  a-cathode-2
*                 |  |  |  |  |  |  |  |  |  |  |  f-cathode-2
*                 |  |  |  |  |  |  |  |  |  |  |  |  common-anode-2
*                 |  |  |  |  |  |  |  |  |  |  |  |  |  common-anode-1
*                 |  |  |  |  |  |  |  |  |  |  |  |  |  |  b-cathode-1
*                 |  |  |  |  |  |  |  |  |  |  |  |  |  |  |  a-cathode-1
*                 |  |  |  |  |  |  |  |  |  |  |  |  |  |  |  |  g-cathode-1
*                 |  |  |  |  |  |  |  |  |  |  |  |  |  |  |  |  |  f-cathode-1
*                 |  |  |  |  |  |  |  |  |  |  |  |  |  |  |  |  |  |
.SUBCKT HDSP_G301 1  2  3  4  5  6  7  8  9  10 11 12 13 14 15 16 17 18

DA1  14 16 dHDSP_G301
DB1  14 15 dHDSP_G301
DC1  14  3 dHDSP_G301
DD1  14  2 dHDSP_G301
DE1  14  1 dHDSP_G301
DF1  14 18 dHDSP_G301
DG1  14 17 dHDSP_G301
DDP1 14  4 dHDSP_G301

DA2  13 11 dHDSP_G301
DB2  13 10 dHDSP_G301
DC2  13  8 dHDSP_G301
DD2  13  6 dHDSP_G301
DE2  13  5 dHDSP_G301
DF2  13 12 dHDSP_G301
DG2  13  7 dHDSP_G301
DDP2 13  9 dHDSP_G301

.MODEL dHDSP_G301 D
+ (
+     IS = 6.04055825E-18
+      N = 1.90788337
+     RS = 23.52447762
+     BV = 40
+    IBV = 100u
+ )

.ENDS HDSP_G301
