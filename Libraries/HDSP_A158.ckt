*
* Diode Model Produced by Altium Ltd
* Date:  3-May-2004
*
* Manufacturer: Renesas
* Component Name: HDSP-A158
*
* Parameters derived from information available in data sheet.
*
*                 common-cathode
*                 |  anode-PLUS
*                 |  |  anode-MINUS
*                 |  |  |  common-cathode
*                 |  |  |  |  anode-DP
*                 |  |  |  |  |  anode-c
*                 |  |  |  |  |  |  anode-b
*                 |  |  |  |  |  |  |
.SUBCKT HDSP_A158 1  2  3  6  7  8  9

DPLUS1  2  1  dHDSP_A158
DMINUS1 3  1  dHDSP_A158
DB1     9  1  dHDSP_A158
DC1     8  1  dHDSP_A158
DDP1    7  1  dHDSP_A158

DPLUS2  2  6  dHDSP_A158
DMINUS2 3  6  dHDSP_A158
DB2     9  6  dHDSP_A158
DC2     8  6  dHDSP_A158
DDP2    7  6  dHDSP_A158

.MODEL dHDSP_A158 D
+ (
+    IS  = 2.08276754E-16
+     N  = 2.17799178
+    RS  = 0.50892350
+    BV  = 14.25
+   IBV  = 100u
+ )

.ENDS HDSP_A158
