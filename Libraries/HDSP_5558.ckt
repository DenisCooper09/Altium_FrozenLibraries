*
* Diode Model Produced by Altium Ltd
* Date:  7-Apr-2004
*
* Manufacturer: Agilent
* Component Name: HDSP-5558
*
* Parameters derived from information available in data sheet.
*
*                 anode-c
*                 |  cathode-c,d
*                 |  |  anode-b
*                 |  |  |  cathode-a,b DP
*                 |  |  |  |  anode-DP
*                 |  |  |  |  |  anode-a
*                 |  |  |  |  |  |  cathode-a,b DP
*                 |  |  |  |  |  |  |  cathode-c,d
*                 |  |  |  |  |  |  |  |  anode-d
*                 |  |  |  |  |  |  |  |  |
.SUBCKT HDSP_5558 1  2  3  4  5  6  7  8  9

DA1  6  4 dHDSP_5558
DB1  3  4 dHDSP_5558
DDP1 5  4 dHDSP_5558

DA2  6  7 dHDSP_5558
DB2  3  7 dHDSP_5558
DDP2 5  7 dHDSP_5558

DC1  1  2 dHDSP_5558
DD1  9  2 dHDSP_5558

DC2  1  8 dHDSP_5558
DD2  9  8 dHDSP_5558

.MODEL dHDSP_5558 D
+ (
+     IS = 7.07436607E-24
+      N = 1.24380258
+     RS = 22.12166762
+     BV = 30
+    IBV = 100u
+ )

.ENDS HDSP_5558
