*
*ZETEX  ZXMD63P03X Mosfet Spice Subcircuit   Last revision 18/8/00
*
* BC 5/1/2004: converted from pspice to spice
*
.SUBCKT ZXMD63P03X 3 4 5
*               D G S
M1 3 2 5 5 M63P03
RG 4 2 18
RL 3 5 1E9
C1 2 5 450E-12
C2 3 2 35E-12
D1 3 5 D63P03
*
.MODEL M63P03 PMOS VTO=-2.32 RS=0.09 RD=0.045 KP=4.2
+CBD=480E-12 LAMBDA=4.9E-3

* .MODEL D63P03 D IS=4E-13 N=1.04 IKF=295E-3 RS=94E-3
 .MODEL D63P03 D (IS=1.0577E-12 N=1.1147 RS=0.0984)

.ENDS ZXMD63P03X
*
*$
