*
* Diode Model Produced by Altium Ltd
* Date:  10-Mar-2004
*
* Manufacturer: Agilent
* Component Name: HDSP-523A
*
* Parameters derived from information available in data sheet.
*
*                 E-anode-1
*                 |  D-anode-1
*                 |  |  C-anode-1
*                 |  |  |  DP-anode-1
*                 |  |  |  |  E-anode-2
*                 |  |  |  |  |  D-anode-2
*                 |  |  |  |  |  |  G-anode-2
*                 |  |  |  |  |  |  |  C-anode-2
*                 |  |  |  |  |  |  |  |  DP-anode-2
*                 |  |  |  |  |  |  |  |  |  B-anode-2
*                 |  |  |  |  |  |  |  |  |  |  A-anode-2
*                 |  |  |  |  |  |  |  |  |  |  |  F-anode-2
*                 |  |  |  |  |  |  |  |  |  |  |  |  common cathode-2
*                 |  |  |  |  |  |  |  |  |  |  |  |  |  common cathode-1
*                 |  |  |  |  |  |  |  |  |  |  |  |  |  |  B-anode-1
*                 |  |  |  |  |  |  |  |  |  |  |  |  |  |  |  A-anode-1
*                 |  |  |  |  |  |  |  |  |  |  |  |  |  |  |  |  G-anode-1
*                 |  |  |  |  |  |  |  |  |  |  |  |  |  |  |  |  |  F-anode-1
*                 |  |  |  |  |  |  |  |  |  |  |  |  |  |  |  |  |  |
.SUBCKT HDSP_523A 1  2  3  4  5  6  7  8  9  10 11 12 13 14 15 16 17 18

DA1  16 14 dHDSP_523A
DB1  15 14 dHDSP_523A
DC1   3 14 dHDSP_523A
DD1   2 14 dHDSP_523A
DE1   1 14 dHDSP_523A
DF1  18 14 dHDSP_523A
DG1  17 14 dHDSP_523A
DDP1  4 14 dHDSP_523A

DA2  11 13 dHDSP_523A
DB2  10 13 dHDSP_523A
DC2   8 13 dHDSP_523A
DD2   6 13 dHDSP_523A
DE2   5 13 dHDSP_523A
DF2  12 13 dHDSP_523A
DG2   7 13 dHDSP_523A
DDP2  9 13 dHDSP_523A

.MODEL dHDSP_523A D
+ (
+    IS  = 4.92088043E-22
+     N  = 1.51994259
+    RS  = 3.79496255
+    BV  = 4.5
+   IBV  = 100u
+ )

.ENDS HDSP_523A
