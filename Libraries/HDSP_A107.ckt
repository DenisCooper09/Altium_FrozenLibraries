*
* Diode Model Produced by Altium Ltd
* Date:  7-Apr-2004
*
* Manufacturer: Agilent
* Component Name: HDSP-A107
*
* Parameters derived from information available in data sheet.
*
*                 common-anode
*                 |  cathode-PLUS
*                 |  |  cathode-MINUS
*                 |  |  |  common-anode
*                 |  |  |  |  cathode-DP
*                 |  |  |  |  |  cathode-c
*                 |  |  |  |  |  |  cathode-b
*                 |  |  |  |  |  |  |
.SUBCKT HDSP_A107 1  2  3  6  7  8  9

DPLUS1  1  2 dHDSP_A107
DMINUS1 1  3 dHDSP_A107
DB1     1  9 dHDSP_A107
DC1     1  8 dHDSP_A107
DDP1    1  7 dHDSP_A107

DPLUS2  6  2 dHDSP_A107
DMINUS2 6  3 dHDSP_A107
DB2     6  9 dHDSP_A107
DC2     6  8 dHDSP_A107
DDP2    6  7 dHDSP_A107

.MODEL dHDSP_A107 D
+ (
+    IS  = 2.08276754E-16
+     N  = 2.17799178
+    RS  = 0.50892350
+    BV  = 14.25
+   IBV  = 100u
+ )

.ENDS HDSP_A107
