*Crystal Subcircuit Parameters
*FREQ = Fundamental frequency
*RS   = Series resistance
*C    = Parallel capacitance
*Q    = Quality Factor

*Raltron R38 32.768KHZ alias:XCRYSTAL {FREQ=32770 RS=18000 C=1.25E-11} pkg:R38
.SUBCKT R38-32.768 1 2 PARAMS: FREQ=32770 RS=18000 C=1.25E-11 Q=1000
LX 1 3 {((Q*RS)/(6.2831852*FREQ))} IC=0.5M
CX 3 4 {(1/(Q*6.2831852*FREQ*RS))}
C0 1 2 {C}
RS 4 2 {RS}
.ENDS
