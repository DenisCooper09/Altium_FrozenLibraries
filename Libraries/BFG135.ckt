* BFG135 SPICE MODEL
* PHILIPS SEMICONDUCTORS
* Date : September 1995
*
* PACKAGE : SOT223A DIE MODEL : BFR134
* 1: COLLECTOR; 2: BASE; 3: EMITTER;
.SUBCKT BFG135 1 2 3
Q1 6 5 7 7 BFR134
* SOT223A parasitic model
               Lb  4 5 1.5n
               Le  7 8 .5n
               L1  2 4 .025n
               L2  1 6 1.19n
               L3  3 8 .6n
              Ccb  4 6 16f
              Cbe  4 8 182f
*
* PHILIPS SEMICONDUCTORS                                       Version:     2.0
* Filename:   BFR134.PRM                                       Date: April 1992  *
.MODEL  BFR134   NPN
+(
+              IS = 6.26489E-015
+              BF = 1.42485E+002
+              NF = 1.00616E+000
+             VAF = 4.48500E+001
+             IKF = 4.47193E+000
+             ISE = 3.79274E-013
+              NE = 2.07719E+000
+              BR = 9.14350E+000
+              NR = 1.05535E+000
+             VAR = 3.00000E+000
+             IKR = 3.62503E-002
+             ISC = 8.32089E-017
+              NC = 1.03925E+000
+              RB = 4.00000E+000
+             IRB = 1.00000E-006
+             RBM = 4.00000E+000
+              RE = 1.19858E+000
+              RC = 1.00000E+000
+              EG = 1.11000E+000
+             XTI = 3.00000E+000
+             CJE = 6.93680E-012
+             VJE = 6.00000E-001
+             MJE = 4.07326E-001
+              TF = 1.11019E-011
+             XTF = 5.41522E+001
+             VTF = 5.75002E+000
+             ITF = 9.98036E-001
+             PTF = -2.0000E+002
+             CJC = 2.17679E-012
+             VJC = 2.78142E-001
+             MJC = 1.72323E-001
+)
.ENDS
