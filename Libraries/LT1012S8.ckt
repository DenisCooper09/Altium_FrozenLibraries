*//////////////////////////////////////////////////////////////////////////////////////
* LT1012S8  Picoamp Input Current, Microvolt Offset, Low Noise Operational Amplifier //
*//////////////////////////////////////////////////////////////////////////////////////
*
* connections:     non-inverting input
*                  |   inverting input
*                  |   |   positive power supply
*                  |   |   |   negative power supply
*                  |   |   |   |   output
*                  |   |   |   |   |
*                  |   |   |   |   |
.SUBCKT LT1012S8   3   2   7   4   6
* INPUT
RC1 7 80 8.842E+03
RC2 7 90 8.842E+03
Q1 80 2 10 QM1
Q2 90 3 11 QM2
DDM1 2 3 DM2
DDM2 3 2 DM2
C1 80 90 5.460E-12
RE1 10 12 2.246E+02
RE2 11 12 2.246E+02
IEE 12 4 6.000E-06
RE 12 0 3.333E+07
CE 12 0 1.579E-12
* INTERMEDIATE
GCM 0 8 12 0 2.841E-11
GA 8 0 80 90 1.131E-04
R2 8 0 1.000E+05
C2 1 8 3.000E-11
GB 1 0 8 0 1.960E+02
* OUTPUT
RO1 1 6 1.000E+02
RO2 1 0 9.000E+02
RC 17 0 1.063E-04
GC 0 17 6 0 9.408E+03
D1 1 17 DM1
D2 17 1 DM1
D3 6 13 DM2
D4 14 6 DM2
VC 7 13 1.785E+00
VE 14 4 1.785E+00
IP 7 4 3.740E-04
DSUB 4 7 DM2
* MODELS
.MODEL QM1 NPN (IS=8.000E-16 BF=2.857E+04)
.MODEL QM2 NPN (IS=8.005E-16 BF=5.455E+04)
.MODEL DM1 D (IS=1.179E-19)
.MODEL DM2 D (IS=8.000E-16)
.ENDS LT1012S8
