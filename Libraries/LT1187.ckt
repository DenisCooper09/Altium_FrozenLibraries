*//////////////////////////////////////////////////////////////////////
* LT1187   Low Power Video Difference Amplifier                      //
*//////////////////////////////////////////////////////////////////////
*
* connections:     non-inverting input
*                  |   inverting input
*                  |   |   positive power supply
*                  |   |   |   negative power supply
*                  |   |   |   |   output
*                  |   |   |   |   |   reference
*                  |   |   |   |   |   |   feedback
*                  |   |   |   |   |   |   |
*                  |   |   |   |   |   |   |
.SUBCKT LT1187     3   2   7   4   6  REF  FB
* LT1187 FRONT END
RL1A 7 1A 500
RL2A 7 5A 500
RE1A 9A 10A 1143
RE2A 6A 8A 1150
I1 9A 4 DC 234UA
I2 10A 4 DC 234UA
I3 6A 4 DC 245UA
I4 8A 4 DC 245UA
Q1A 1A 3 9A MOD1
Q2A 5A 2 10A MOD2
Q3A 1A REF 6A MOD1
Q4A 5A FB 8A MOD2
RCM1 9A 0 10MEG
RCM2 6A 0 10MEG
CCM1 9A 0 .4PF
CCM2 6A 0 .4PF
CIN1 2 3 2PF
CIN2 REF FB 2PF
.MODEL MOD1 NPN BF=500 IS=1.00E-16
.MODEL MOD2 NPN BF 550 IS=1.04E-16
*
* INPUT
RC1 7  80 8.8419E+01
RC2 7  90 8.8419E+01
Q1  80 1A  10 QM1
Q2  90 5A  11 QM2
CIN 2  3  1.0000E-13
C1  80 90 1.5000E-11

*RE1 10 12 +7.8281E+01
*RE2 11 12 +7.8281E+01
*jg, 5/7/2000: syntax error corrected

RE1 10 12  7.8281E+01
RE2 11 12  7.8281E+01
IEE 12 4  5.1000E-03
RE  12 0  3.9216E+04
* INTERMEDIATE
GCM 0  8  12 0  2.2566E-08
GA  8  0  80 90 1.1310E-02
R2  8  0  1.0000E+05
C2  1  8  18.000E-12
GB  1  0  8  0  9.8244E-01
RO2 1  0  9.0000E+00
* OUTPUT
RSO 1  6  1.0000E+00
ECL 18 0  1  6  2.8561E+01
GCL 0  8  20 0  1.0000E+00
RCL 20 0  1.0000E+01
D1  18 19 DM1
VOD1 19 20 0.0000E+00
D2  20 21 DM1
VOD2 21 18 0.0000E+00
*
D3A 131 70 DM3
D3B 13 131 DM3
GPL 0  8  70 7  1.0000E+00
VC  13 6  2.5416E+00
RPLA 7  70 1.0000E+01
RPLB 7  131 1.0000E+03
D4A 60 141 DM3
D4B 141 14  DM3
GNL 0  8  60 4  1.0000E+00
VE  6  14 2.0416E+00
RNLA 60 4  1.0000E+01
RNLB 141 4  1.0000E+03
*
IP  7  4  6.9000E-03
DSUB 4  7  DM2
* MODELS
.MODEL QM1 NPN (IS=8.0000E-16 BF=1.7000E+09)
.MODEL QM2 NPN (IS=8.0003E-16 BF=5.1000E+09)
.MODEL DM1  D   (IS=1.0000E-20)
.MODEL DM2  D   (IS=8.0000E-16 BV=2.1600E+01)
.MODEL DM3  D   (IS=1.0000E-16)
.ENDS LT1187
