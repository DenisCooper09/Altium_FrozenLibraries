*Crystal Subcircuit Parameters
*FREQ = Fundamental frequency
*RS   = Series resistance
*C    = Parallel capacitance
*Q    = Quality Factor

*Raltron RSM200S 32.768KHZ alias:XCRYSTAL {FREQ=32770 RS=50000 C=1.25E-11} pkg:RSM200S
.SUBCKT RSM200S32.76 1 2 PARAMS: FREQ=32770 RS=50000 C=1.25E-11 Q=1000
LX 1 3 {((Q*RS)/(6.2831852*FREQ))} IC=0.5M
CX 3 4 {(1/(Q*6.2831852*FREQ*RS))}
C0 1 2 {C}
RS 4 2 {RS}
.ENDS
