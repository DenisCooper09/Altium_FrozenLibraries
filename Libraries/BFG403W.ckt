.SUBCKT BFG403W 1 2 3
L1   2 5 1.1E-09
L2   1 4 1.1E-09
L3   3 6 0.25E-09
Ccb  4 5 2.0E-15
Cbe  5 6 80.0E-15
Cce  4 6 80.0E-15
Cbpb 5 7 1.45E-13
Cbpc 4 8 1.45E-13
Rsb1 6 7 25
Rsb2 6 8 19
Q1 4 5 6 6 BFG403W

.MODEL BFG403W NPN
+(
+ IS = 5.554E-18
+ BF = 145
+ NF = 0.9934
+ VAF = 31.12
+ IKF = 35.75E-03
+ ISE = 3.535E-14
+ NE = 3
+ BR = 11.37
+ NR = 0.985
+ VAR = 1.874
+ IKR = 14.3E-03
+ ISC = 5.708E-17
+ NC = 1.546
+ RB = 122.38
+ IRB = 0
+ RBM = 52.45
+ RE = 1.511
+ RC = 15.119
+ CJE = 3.661E-14
+ VJE = 0.9
+ MJE = 0.3456
+ CJC = 1.621E-14
+ VJC = 0.5569
+ MJC = 0.2079
+ CJS = 7.859E-14
+ VJS = 0.4183
+ MJS = 0.2391
+ XCJC = 0.5
+ TR = 0.0
+ TF = 4.122E-12
+ XTF = 68.2
+ VTF = 2.004
+ ITF = 0.1796
+ PTF = 0
+ FC = 0.5501
+ EG = 1.11
+ XTI = 3
+ XTB = 1.5
+)
.ENDS
