* jjt 7/8/2000: commented out the first model since its Vz is radically different to the
*               datasheet.
**MMBZ5258BLT1 MCE 6/20/97
**Ref: Motorola TVS/Zener Databook, Q2/94
**8.7V 1000mW Si Zener pkg:SOT-23 1,3
*.SUBCKT MMBZ5258BLT1 1 2
**    TERMINALS:  A K
*D1 1 2  DF
*DZ 3 1  DR
*VZ 2 3  8.151
*.MODEL DF D (IS=5.02N RS=42M N=1.7 CJO=85P VJ=0.75 M=0.33 TT=50.1N)
*.MODEL DR D (IS=230U RS=2.4 N=4.3)
*.ENDS
** Origin: Mcediode.lib

* <<<<< Note: Two instances of the same model with differing parameters  >>>>>
*MMBZ5258BLT1 MCE 6/20/97
*Ref: Motorola TVS/Zener Databook, Q2/94
*36V 1000mW Si Zener pkg:SOT-23 1,3
.SUBCKT MMBZ5258BLT1 1 2
*    TERMINALS:  A K
D1 1 2  DF
DZ 3 1  DR
VZ 2 3  35.42
.MODEL DF D (IS=5.02N RS=42M N=1.7 CJO=41.4P VJ=1 M=0.33 TT=50.1N)
.MODEL DR D (IS=169U RS=21 N=6.4)
.ENDS
* Origin: Mcediode.lib
