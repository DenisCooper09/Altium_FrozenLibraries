*EL2099 Macromodel
* Revision A, July 1992
* Connections:          +input
*                       |   -input
*                       |   |   +Vsupply
*                       |   |   |   -Vsupply
*                       |   |   |   |   output
*                       |   |   |   |   |
.subckt EL2099          4   5   1   3   2
*
* Input Stage
*
e1  10 0 4 0 1.0
vis 10  9 0V
h2   9 12 vxx 1.0
r1  5  11 50
l1 11  12 48nH
iinp 4  0 5uA
iinm 5  0 -8uA
*
* Slew Rate Limiting
*
h1 13 0 vis 600
r2 13 14 1K
d1 14  0  dclamp
d2  0 14  dclamp
*
* High Frequency Pole
*
e2 30 0 14 0 0.00166666666
l3 30 17 1.5uH
c5 17 0 1pF
r5 17 0 500
**
* Transimpedance Stage
*
g1 0 18 17 0 1.0
rol 18 0 150K
cdp 18 0 8pF
*
* Output Stage
*
q1 3 18 19 qp
q2 1 18 20 qn
q3 1 19 21 qn
q4 3 20 22 qp
r7 21 2  1
r8 22 2  1
ios1 1 19 5mA
ios2 20 3 5mA
*
* Supply Current
*
ips 1 3 19mA
*
* Error Terms
*
ivos 0 23 5mA
vxx 23  0 0V
e4  24 0 4 0 1.0
e5  25 0 1 0 1.0
e6  26  0 3 0 1.0
r9  24 23 3K
r10 25 23 1K
r11 26 23 1K
*
* Models
*
.model qn npn(is=5e-15 bf=200 tf=0.1nS)
.model qp pnp(is=5e-15 bf=200 tf=0.1nS)
.model dclamp d(is=1e-30 ibv=0.266 bv=5 n=4)
.ends
