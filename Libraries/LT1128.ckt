*//////////////////////////////////////////////////////////////////////
* LT1128 Ultra Low Noise Precision High-Speed Operational Amplifier  //
*//////////////////////////////////////////////////////////////////////
*
* connections:     non-inverting input
*                  |   inverting input
*                  |   |   positive power supply
*                  |   |   |   negative power supply
*                  |   |   |   |   output
*                  |   |   |   |   |   COMP
*                  |   |   |   |   |   |
*                  |   |   |   |   |   |
.SUBCKT LT1128     1   2   3   4   5   6
*
DIP1 1 114 DX
DIP2 114 2 DX
DIP3 2 115 DX
DIP4 115 1 DX
CIN 1 2 5.0000e-012
GRIN 1 2 1 2 4.9541e-005
Q1 11 2 13 Q1
Q2 12 111 14 Q2
GRC1 3 11 3 11 1.0392e-003
GRC2 3 12 3 12 1.0392e-003
GRE1 10 13 10 13 2.0652e-001
GRE2 10 14 10 14 2.0652e-001
C1 11 12 2.0675e-012
IEE 10 4 DC 2.0785e-003
GSR 10 4 12 11 1.4694e-004
D1 4 10 DX
GA 60 99 11 12 1.0392e-003
FRI1 99 1 VRI1 1
VRI1 101 0 DC 0
RRI1 101 0 1.6822e+004
FRI2 99 2 VRI2 1
VRI2 201 0 DC 0
RRI2 201 0 1.6822e+004
GR 99 60 605 606 9.4245e-001
IR1 0 605 DC 1
IR2 0 606 DC 1
DR1 605 0 DR
DR2 606 0 DR
GCM1 99 20 POLY(2) 1 99 2 99 0 5.0000e-004 5.0000e-004
RCM1 21 99 1.000000e+003
RCM2 20 99 1.0000e+006
LCM 20 21 2.2736e+000
ECM 111 1 20 99 5.0119e-007
RP1 601 99 2.0000e+003
CP1 60 601 1.3263e-011
RP11 60 99 1.0000e+004
GP1 99 61 60 99 1.0000e-004
RP2 611 99 1.2500e+004
LP2 61 611 2.4868e-004
RP22 61 99 5.0000e+004
GP2 99 6 61 99 1.0000e-004
R2 6 99 1.0000e+003
C2 6 7 2.9900e-010
GB 7 99 6 99 6.0452e+004
R01 7 99 1.4675e+001
R02 7 50 1.0000e-001
R03 50 5 6.5225e+001
R04 5 99 1.0000e+012
VC 53 50 DC 3.1000e+000
VE 54 50 DC -3.1000e+000
DC1 53 55 DX
DC2 55 56 DX
DE1 57 54 DX
DE2 58 57 DX
GVC1 3 56 3 56 1.0E-4
GVE1 4 58 4 58 1.0E-4
GVC2 3 55 3 55 1.0E-5
GVE2 4 57 4 57 1.0E-5
GVLP 99 60 56 3 1.0000e+000
GVLN 99 60 58 4 1.0000e+000
ECLP 91 0 7 50 2.5000e+002
ECLN 92 0 7 50 2.5000e+002
DCLP 91 90 DX
DCLN 90 92 DX
VLIM 90 0 DC 0
FB 7 99 VLIM 2.4860e+003
EGND 99 0 POLY(2) 3 0 4 0 0 0.5 0.5
DSUB 4 3 DX
IP 3 4 DC 5.5215e-003
GV 31 0 7 50 1.0000e+001
DP1 3 31 DX
DP2 33 4 DX
RGV 32 33 10.0
EGV 31 32 POLY(1) 3 4 -0.85 1.0
.MODEL DX D IS=8.0000e-016 RS=0 XTI=0
.MODEL Q1 NPN IS=9.9962e-016 BF=33523.6 XTB=1.1751e+000
+ XTI=2.99980e+000 KF=1.6889e-014
.MODEL Q2 NPN IS=1.0004e-015 BF=69282.0 XTB=1.0246e+000
+ XTI=3.00020e+000 KF=1.6889e-014
.MODEL DR D IS=8.0000e-016 KF=2.4366e-018 RS=0 XTI=0
*
.ENDS LT1128
*
