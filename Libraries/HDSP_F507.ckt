*
* Diode Model Produced by Altium Ltd
* Date:  10-Mar-2004
*
* Manufacturer: Agilent
* Component Name: HDSP-F507
*
* Parameters derived from information available in data sheet.
*
*                 common-anode
*                 |  cathode-PLUS
*                 |  |  cathode-MINUS
*                 |  |  |  common-anode
*                 |  |  |  |  cathode-DP
*                 |  |  |  |  |  cathode-c
*                 |  |  |  |  |  |  cathode-b
*                 |  |  |  |  |  |  |
.SUBCKT HDSP_F507 1  2  3  6  7  8  9

DPLUS1  1 2 dHDSP_F507
DMINUS1 1 3 dHDSP_F507
DB1     1 9 dHDSP_F507
DC1     1 8 dHDSP_F507
DDP1    1 7 dHDSP_F507

DPLUS2  6 2 dHDSP_F507
DMINUS2 6 3 dHDSP_F507
DB2     6 9 dHDSP_F507
DC2     6 8 dHDSP_F507
DDP2    6 7 dHDSP_F507

.MODEL dHDSP_F507 D
+ (
+     IS = 1.61114016E-27
+      N = 1.30291189
+     RS = 12.83456794
+     BV = 50
+    IBV = 100u
+ )

.ENDS HDSP_F507
