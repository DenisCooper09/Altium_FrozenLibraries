*BZG03C270 MCE 4/7/98
*Ref: Temic Semiconductor Short Form, 1996
*270V 3W Si Zener pkg:DO214 1,2
.SUBCKT BZG03C270 1 2
*    TERMINALS:  A K
D1 1 2  DF
DZ 3 1  DR
VZ 2 3  269
.MODEL DF D (IS=15.1N RS=14M N=1.7 CJO=25.6P VJ=1 M=0.33 TT=50.1N)
.MODEL DR D (IS=944U RS=143 N=26)
.ENDS
