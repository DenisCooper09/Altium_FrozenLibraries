.SUBCKT BSS123 1 2 3
Cgs  2 3 18.8E-12
Cgd1 2 4 57.7E-12
Cgd2 1 4 4E-12
M1 1 2 3 3 MOST1 W=7.9m L=2u
M2 4 2 1 3 MOST2 W=7.9m L=2u
D1 3 1 Dbody
.MODEL MOST1 NMOS(Level=3 Kp=20.79u Rs=20m Vto=1.6 Rd=1.515)
.MODEL MOST2 NMOS(VTO=-4.64 Kp=20.79u Rs=20m)
.MODEL Dbody D(Is=192.2f N=1.052 Rs=318.2m Cjo=72.35p M=422.8m Vj=494.8m
+            Bv=100 Ibv=10u Tt=140n)
.ENDS
