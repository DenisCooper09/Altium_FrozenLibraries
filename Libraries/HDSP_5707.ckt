*
* Diode Model Produced by Altium Ltd
* Date:  6-Apr-2004
*
* Manufacturer: Agilent
* Component Name: HDSP-5707
*
* Parameters derived from information available in data sheet.
*
*                 cathode-c
*                 |  anode-c, d
*                 |  |  cathode-b
*                 |  |  |  anode-a, b, DP
*                 |  |  |  |  cathode-DP
*                 |  |  |  |  |  cathode-a
*                 |  |  |  |  |  |  anode-a, b, DP
*                 |  |  |  |  |  |  |  anode-c, d
*                 |  |  |  |  |  |  |  |  cathode-d
*                 |  |  |  |  |  |  |  |  |
.SUBCKT HDSP_5707 1  2  3  4  5  6  7  8  9

DA1   4  6 dHDSP_5707
DB1   4  3 dHDSP_5707
DDP1  4  5 dHDSP_5707

DA2   7  6 dHDSP_5707
DB2   7  3 dHDSP_5707
DDP2  7  5 dHDSP_5707

DC1   2  1 dHDSP_5707
DD1   2  9 dHDSP_5707

DC2   8  1 dHDSP_5707
DD2   8  9 dHDSP_5707

.MODEL dHDSP_5707 D
+ (
+     IS = 1.82902372E-24
+      N = 1.34581490
+     RS = 23.36447097
+     BV = 40
+    IBV = 100u
+ )

.ENDS HDSP_5707
