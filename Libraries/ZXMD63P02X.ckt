*
*ZETEX  ZXMD63P02X Mosfet Spice Subcircuit   Last revision 18/8/00
*
* BC 5/1/2004: converted from pspice to spice
*
.SUBCKT ZXMD63P02X 3 4 5
*               D G S
M1 3 2 5 5 M63P02
RG 4 2 18
RL 3 5 1E9
C1 2 5 700E-12
C2 3 2 55E-12
D1 3 5 D63P02
*
.MODEL M63P02 PMOS VTO=-1.37 RS=0.08 RD=0.04 KP=8
+CBD=700E-12 LAMBDA=9E-3

* .MODEL D63P02 D IS=4E-12 N=1.04 IKF=44E-3 RS=96E-3
.MODEL D63P02 D (IS=6.6409E-11 N=1.2575 RS=0.1094)

.ENDS ZXMD63P02X
*
*$
