*ZETEX  BCX38B Darlington Spice Subcircuit   Last revision  19/6/95
*
.SUBCKT BCX38B 1 2 3
*              C B E
Q1 1 2 4 SUB38B
Q2 1 4 3 SUB38B 12.75
*
.MODEL SUB38B NPN IS =1.1E-14 ISE=7.1E-15 NF =1.012 NE =1.4758 BF =147 IKF=.12
+BR =15 IKR=.05 RE =1.3 RC =.5 RB =.3 VAF=150 CJE=14.5E-12 CJC=4.14E-12
+VJC=.515 MJC=.26 TF =1.15E-9 TR =75E-9
.ENDS BCX38B
*
*                          (C)  1991 ZETEX PLC
*
*   The copyright in this model  and  the design embodied belong to
*   Zetex PLC ("Zetex"). It is supplied free of charge by Zetex for
*   the purpose  of research  and design  and may be used or copied
*   intact (including this notice) for that purpose only. All other
*   rights  are  reserved.  The model  is believed  accurate but no
*   condition or warranty as to its  merchantability or fitness for
*   purpose  is  given  and  no liability  in respect of any use is
*   accepted by Zetex PLC, its distributors or agent.
*
*
*   Zetex PLC, Fields New Road, Chadderton, Oldham  OL9 8NP
