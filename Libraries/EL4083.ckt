*EL4083 Macromodel
*Revision A, August 22, 1994
*
*Connection:   IZ(BIAS)
*               |   IX(in)
*               |   |   IY(in)
*               |   |   |   VEE
*               |   |   |   |   VCC
*               |   |   |   |   |   IXY
*               |   |   |   |   |   |   /IXY
*               |   |   |   |   |   |   |
.subckt EL4083 ZIN XIN YIN VEE VCC IXY IYX
.MODEL M1MP5DIODE D TT=60p IS=1f CJO=300f VJ=600m XTI=3 EG=1.11 RS=80m
.MODEL M2MDCAP D TT=100n IS=2e-17 CJO=1p VJ=800m RS=300
.MODEL M3MNPN1 NPN CJC=1.3p TF=120p IS=1.04f BF=120 CJS=480f
.MODEL M4MPNP1 PNP CJC=1.79p TF=50.166666666667p IS=1f BF=90 CJS=480f
C1 N9 N7 9p
C2 N7 0 350f
C3 N19 N16 9p
C4 N16 0 350f
D1 0 N15 M2MDCAP 12
D10 0 N26 M1MP5DIODE 1
D11 N26 N27 M1MP5DIODE 1
D12 N29 N30 M1MP5DIODE 1
D13 0 N31 M1MP5DIODE 1
D14 VBP N34 M1MP5DIODE 2
D15 N34 VBP M1MP5DIODE 2
D16 0 N34 M2MDCAP 12.5
D17 N35 0 M2MDCAP 12.5
D18 N35 VBN M1MP5DIODE 2
D19 VBN N35 M1MP5DIODE 2
D2 N15 0 M2MDCAP 12
D20 N42 N10 M2MDCAP 4
D21 N10 0 M2MDCAP 4
D22 0 N20 M2MDCAP 4
D23 N20 N45 M2MDCAP 4
D3 0 N12 M1MP5DIODE 8
D4 N55 N13 M1MP5DIODE 8
D5 0 N25 M2MDCAP 6
D6 N25 0 M2MDCAP 6
D7 0 N22 M1MP5DIODE 8
D8 N54 N23 M1MP5DIODE 8
D9 0 N28 M1MP5DIODE 1
EV94 0 VBN 0 N45 1
EV95 VBP 0 N42 0 1
EV96 N54 0 N21 0 650m
EV97 N55 0 N11 0 650m
EV98 N27 0 N28 0 1
EV99 N29 0 SWIN 0 1
FI10 VN- VEE VFI10 1
FI11 VCC VP- VFI11 1
FI12 VCC N39 VFI12 1
FI13 N37 VEE VFI13 1
FI14 VCC N38 VFI14 1
FI15 N36 VEE VFI15 1
FI16 N45 VEE VFI16 1
FI17 VCC N42 VFI17 1
FI18 N37 N36 VFI18 500m
FI19 N38 N39 VFI19 500m
FI20 VN+ VN- VFI20 500m
FI21 VP+ VP- VFI21 500m
FI22 0 N21 VFI22 1
FI23 N21 0 VFI23 1
FI24 N24 0 VFI24 2
FI25 N14 0 VFI25 2
FI26 N11 0 VFI26 1
FI27 0 N11 VFI27 1
FI28 VCC VEE VFI28 21
FI29 N28 ZB1 VFI29 1
FI5 N33 0 VFI5 1
FI6 0 N33 VFI6 1
FI7 N35 N34 VFI7 1
FI8 VN+ VEE VFI8 1
FI9 VCC VP+ VFI9 1
IIBGN 0 VEE 2.2m
IIBGP VCC 0 2.46m
IIISWB N32 VEE 629u
IIISWI SWIN VEE 555u
IIZSU N28 VEE 10u
L1 N7 IXA 71n
L2 XIN N7 4n
L3 N16 IYA 71n
L4 YIN N16 4n
L5 N46 IYX 4n
L6 N47 IXY 4n
Q1 0 N10 VP+ VEE M4MPNP1 2
Q10 N46 VN+ N36 VEE M3MNPN1 2
Q11 N47 VN+ N37 VEE M3MNPN1 2
Q12 N46 VN- N37 VEE M3MNPN1 2
Q13 0 N34 N56 VEE M4MPNP1 400m
Q14 0 N34 N57 VEE M4MPNP1 400m
Q15 0 N35 N58 VEE M3MNPN1 400m
Q16 0 N35 N59 VEE M3MNPN1 400m
Q2 0 N10 VP- VEE M4MPNP1 2
Q3 0 N20 VN+ VEE M3MNPN1 2
Q4 0 N20 VN- VEE M3MNPN1 2
Q5 N46 VP- N39 VEE M4MPNP1 2
Q6 N47 VP+ N39 VEE M4MPNP1 2
Q7 N46 VP+ N38 VEE M4MPNP1 2
Q8 N47 VP- N38 VEE M4MPNP1 2
Q9 N47 VN- N36 VEE M3MNPN1 2
R1 N15 N7 60
R10 N16 N17 450
R11 YIN N16 100
R12 0 SWIN 500
R13 N56 N38 35
R14 N57 N39 35
R15 N37 N58 35
R16 N36 N59 35
R17 N46 IYX 100
R18 N47 IXY 100
R2 N11 IXC 6.25
R3 N9 IXC 4.5
R4 N7 IXA 1.5K
R5 XIN N7 100
R6 N25 N16 156
R7 N21 IYC 6.25
R8 IYC N19 45
R9 N17 IYA 45
RSU VEE 0 16K
VFI10 N43 N44 0.0
VFI11 N40 N41 0.0
VFI12 ZB4 ZB5 0.0
VFI13 ZB5 ZB6 0.0
VFI14 ZB3 ZB4 0.0
VFI15 ZB6 ZB7 0.0
VFI16 N44 ZB9 0.0
VFI17 N41 ZB8 0.0
VFI18 IYB IYC 0.0
VFI19 IYA IYB 0.0
VFI20 IXB IXC 0.0
VFI21 IXA IXB 0.0
VFI22 N22 N24 0.0
VFI23 N23 N24 0.0
VFI24 ZB2 ZB3 0.0
VFI25 ZB1 ZB2 0.0
VFI26 N13 N14 0.0
VFI27 N12 N14 0.0
VFI28 ZB9 VEE 0.0
VFI29 ZIN N26 0.0
VFI5 N30 N32 0.0
VFI6 N31 N32 0.0
VFI7 N33 0 0.0
VFI8 ZB8 N43 0.0
VFI9 ZB7 N40 0.0
.ENDS
