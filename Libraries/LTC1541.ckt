*//////////////////////////////////////////////////////////////////////
* LTC1541 Micropower Operational Amplifier, Comparator and Reference //
*//////////////////////////////////////////////////////////////////////
* jjt 7/1/2002: converted temp. coeffs to Spice3 syntax.
*
*        Model connections:
*
*                  AMPOUT
*                  |   AMPIN-
*                  |   |   AMPIN+
*                  |   |   |   VSS
*                  |   |   |   |   COMPIN+
*                  |   |   |   |   |   REF
*                  |   |   |   |   |   |   COMPOUT
*                  |   |   |   |   |   |   |   VDD
*                  |   |   |   |   |   |   |   |
.SUBCKT LTC1541    1   2   3   4   5   6   7   8
XOP  3 2 8 4 1  LTC1541_OP
XCOMP  5 6 7 8 4  LTC1541_COMP
XREF  6 8 4  LTC1541_REF
.ENDS LTC1541
*
***
*
*   low power CMOS op amp
.SUBCKT LTC1541_OP 1 2 3 4 5
*
* input stage
CIN 1 2 3.8021e-012
GRIN 1 2 1 2 1.0000e-010
M1 11 2 10 10 M1 L=100U W=100U
M2 12 111 10 10 M2 L=100U W=100U

*RD1 4 11 1.6000e+006 TC=2.0469e-005
RD1 4 11 1.6000e+006 RD1MOD
.MODEL RD1MOD R (TC1=2.0469e-005)

*RD2 4 12 1.6000e+006 TC=-2.0469e-005
RD2 4 12 1.6000e+006 RD2MOD
.MODEL RD2MOD R (TC1=-2.0469e-005)

DI1 111 3 DI1
DI2 2 3 DI2
C1 11 12 3.1085e-012
IEE 3 10 DC 1.2500e-006
GA 60 99 11 12 6.2500e-007
*
* common mode rejection
GCM1 99 20 POLY(2) 1 99 2 99 0 5.0000e-004 5.0000e-004
RCM1 21 99 1.000000e+003
RCM2 20 99 1.0000e+006
LCM 20 21 5.3052e-001
ECM 111 1 20 99 3.1623e-006
*
* frequency shaper
RR1 6 60 1.0000e-003
*
* output stage
R2 6 99 1.0000e+003
C2 6 7 1.5625e-010
GB 7 99 6 99 3.9216e+005
R01 7 99 9.9900e+001
R02 7 50 1.0000e-001
R03 50 5 5.0000e+002
R04 5 99 5.9379e+009
VC 53 50 DC 9.5737e-001
VE 54 50 DC -9.3738e-001
DC1 53 55 DX
DC2 55 56 DX
DE1 57 54 DX
DE2 58 57 DX
GVC1 3 56 3 56 1.0E-4
GVE1 4 58 4 58 1.0E-4
GVC2 3 55 3 55 1.0E-5
GVE2 4 57 4 57 1.0E-5
GVLP 99 60 56 3 1.0000e+000
GVLN 99 60 58 4 1.0000e+000
ECLP 91 0 7 50 5.5556e+003
ECLN 92 0 7 50 5.5556e+003
DCLP 91 90 DX
DCLN 90 92 DX
VLIM 90 0 DC 0
FB 7 99 VLIM 9.3945e+000
*
* supply characteristic
EGND 99 0 POLY(2) 3 0 4 0 0 0.5 0.5
DSUB 4 3 DX
IP 3 4 DC 1.2500e-006
*
GV 31 0 7 50 1.0000e+001
DP1 3 31 DX
DP2 33 4 DX
RGV 32 33 9.7531
EGV 31 32 POLY(1) 3 4 -0.8 1.0
*
.MODEL DX D (IS=8.2592e-016 RS=0 XTI=0)
.MODEL M1 PMOS (LEVEL=3 KP=1.3093e-004 VTO=-9.996500e-001 KF=1.2612e-044)
.MODEL M2 PMOS (LEVEL=3 KP=1.3093e-004 VTO=-1.000350e+000 KF=1.2612e-044)
.MODEL DI1 D (IS=1.4726e-011 EG=8.3479e-001 XTI=3.0000e+000)
.MODEL DI2 D (IS=1.0997e-011 EG=8.7734e-001 XTI=3.0000e+000)
.MODEL DRI D (IS=8.2592e-016 KF=1.5623e-017 RS=0 XTI=0)
*
.ENDS LTC1541_OP
*
***
*
*   low power CMOS comparator
*   with internal hysteresis
.SUBCKT LTC1541_COMP 1 2 101 200 300
*
* input stage
CIN_D 2 1 5.0000e-012
CIN_CM1 1 0 3.5000e-012
CIN_CM2 2 0 3.5000e-012
RIN 2 1 1.1000e+011
*ROFF1 301 0 1.0005e+000 TC=6.5000e-006
ROFF1 301 0 1.0005e+000 ROFF1MOD
.MODEL ROFF1MOD R (TC1=6.5000e-006)

ROFF2 302 0 1.0000e+000
IOFF1 0 301 DC 1
IOFF2 0 302 DC 1
EOFF 1 3 POLY(3) 301 302 1 0 2 0 0 1.0 1.2559e-004 1.2559e-004
ROFF 3 1 1.0000e+009
IBP 303 0 DC 9.3132e-011
*RBP 303 0 1E6 TC=1.6842e-001
RBP 303 0 1E6 RBPMOD
.MODEL RBPMOD R (TC1=1.6842e-001)

GBP 1 0 303 0 1e-6
IBN 304 0 DC 5.7291e-011
*RBN 304 0 1E6 TC=1.6842e-001
RBN 304 0 1E6 RBNMOD
.MODEL RBNMOD R (TC1=1.6842e-001)

GBN 2 0 304 0 1e-6
*
* internal hysteresis
ITRIP 300 353 3.0E-6
RTRIP 353 300 1.0E3
RNORM1 200 356 1.0E9
RNORM2 300 356 1.0E9
GNORM 300 357 101 356 1.0
CNORM 357 300 2.2E-11
RNORM3  357 300 1.0E3
DNORM1 357 358 DPC
VNORM1 358 300 DC 0.075
DNORM2 359 357 DPC
VNORM2 359 300 DC -0.075
GMULT 300 360 POLY(2) 357 300 353 300 0 0 0 0 -1.0E-3
RMULT 360 300 1.0E3
EHYST 5 2 360 300 1.0
RHYST 5 2 1.0E9
*
* delay stage
G1 0 20 3 5 1.0000e+001
R1 20 0 1.0000e+003
D1P 20 21 DX
D1N 22 20 DX
V1P 21 0 DC 1.2000e+003
V1N 22 0 DC -1.2000e+003
G2 0 23 20 0 1.0000e-003
R2 23 0 1.0000e+003
CD 23 0 5.3866e-009
*
* slewrate stage
G3 0 24 23 0 1.0000e-003
R3 24 0 1.0000e+003
D3P 24 25 D3P
D3N 26 24 D3N
V3P 25 0 DC 1.6627e+002
V3N 26 0 DC -1.0982e+002
G41 0 30 24 0 1.0000e-003
R41 30 0 1.0000e+003
CR 30 0 8.1016e-008
D4P 30 32 DX
D4N 33 30 DX
E4P 32 0 POLY(1) 200 300 -6.9760e-001 5.0000e-001
E4N 0 33 POLY(1) 200 300 -6.9760e-001 5.0000e-001
*
* phase shifter
G5 0 40 30 0 1.0000e-003
R5 40 0 1.0000e+003
LA 40 41 3.1831e-005
CA 41 0 1.9894e-010
*
* output stage
GO11 401 42 41 0 2.5000e-002
RO11 42 401 4.0000e+001
DO1 42 43 DOUT
GO12 401 43 41 0 1.9994e-002
RO12 43 401 5.0015e+001
VOUT1 101 43 DC -7.397406e-003
ROUT1 101 0 1.0000e+009
*
* supply characteristic
EGND 401 0 POLY(2) 200 0 300 0 0 5.0000e-001 5.0000e-001
IVDD 200 300 DC 2.5000e-006
FA1 51 0 VOUT1 -1
DAP 200 51 DPC
RGV 52 53 9.7531
EGV 51 52 POLY(1) 200 300 -0.8 1.0
DAN 53 300 DPC
*
.MODEL DX D (IS=1e-12 RS=0 XTI=0)
.MODEL DPC D (IS=8.2592e-016 RS=0 XTI=0)
.MODEL D3P D (IS=1e-12 TT=2.5533e-006 CJO=0.3E-12 RS=0 XTI=0)
.MODEL D3N D (IS=1e-12 TT=3.5654e-006 CJO=0.3E-12 RS=0 XTI=0)
.MODEL DOUT D (IS=8.0e-7 RS=0 XTI=0.0 N=0.1 EG=0.1)
*
.ENDS LTC1541_COMP
*
***
*
*   1.2 V bandgap reference
*   with temperature drift
.SUBCKT LTC1541_REF 420 200 300
*
* reference
IREF1 300 400 1.0E-3
RREF1 400 300 1.0E3
IREF2 300 401 1.0E-3
*RREF2 401 300 1.0E3 TC=-1.5E-5
RREF2 401 300 1.0E3 RREF2MOD
.MODEL RREF2 R (TC1=-1.5E-5)

GREF 300 410 POLY(2) 400 300 400 401 1.2E-3 0 0 0 0 -1.0
RREF3 410 300 1.0E3
CREF 410 300 1.0E-11
*
* transient characteristic
CTRAN1 200 404 1.0E-9
RTRAN1 404 300 1.0E6
GTRAN1 405 300 POLY(1) 404 300 0 0 1.0E-4
RTRAN2 405 300 1.0E3
CTRAN2 405 300 3.0E-7
GTRAN2 410 300 405 300 -2.5E-6
*
DVCP 410 409 DY
EVCP 409 300 POLY(1) 200 300 -0.725 0.7
DVCN 408 410 DY
VVCN 408 300 DC 0.908
*
* output stage
EOUT 411 300 410 300 1.0
ROUT1 411 412 1.0
VSENS 412 420 DC 0
ROUT2 420 300 1.0E9
*
* !!! required for correct initial solution due to
* !!! negative resistance characteristic of output
.NODESET V(412)=1.2
*
* sourcing characteristic
FBGR1 300 421 VSENS 10
RBGR1 421 300 1.0E3
DBGR1 421 422 DY
RBGR2 422 300 1.0E4
DBGR2 421 423 DY
VBGR1 423 424 DC 23
RBGR3 424 300 1.0E4
*
* sinking characteristic
FBGR2 300 431 VSENS -360
RBGR4 431 300 1.0E3
DBGR3 431 432 DY
RBGR5 432 300  1.0E4
DBGR4 431 433 DY
VBGR2 433 434 DC 13.5
RBGR6 434 300 1.0E4
*
GDROP 410 300 POLY(2) 422 300 432 300 0 -2.30E-7 2.18E-7
GLIM  410 300 POLY(2) 424 300 434 300 0 0 0 -1.0E-3 0 1.0E-4
*
.MODEL DY D IS=8.0000e-016 RS=0 XTI=0
*
.ENDS LTC1541_REF
*
***
*
