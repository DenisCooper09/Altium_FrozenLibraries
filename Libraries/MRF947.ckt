*MRF947
*Motorola NPN Low Noise, High-Frequency Transistor
********************
* Version 1.1.1b
.SUBCKT MRF947 100 200 300
LCL 100 199 3.4E-10
LBL 200 201 2.9E-10
LBB 201 299 7.8E-10
LEL 300 301 2.9E-10
LEB 301 399 7.8E-10
CCB 201 199 4E-14
CCE 199 301 2.2E-13
CBE 201 301 1.2E-13
X1 199 299 399 RF947
.ENDS MRF947
*
.SUBCKT RF947 1 2 3
CBPAD 2 1 6.5E-14
CEPAD 1 3 13.0E-14
Q1 1 2 3 DMRF947
*
.MODEL DMRF947 NPN
+ IS = 4.536E-16
+ BF = 130
+ NF = 1.003
+ VAF = 24
+ IKF = 0.8
+ ISE = 7.238E-13
+ NE = 2.577
+ BR = 21
+ NR = 1
+ VAR = 3.3
+ IKR = 0.022
+ ISC = 1.71E-15
+ NC = 1.202
+ RB = 8
+ IRB = 8E-05
+ RBM = 8
+ RE = 0.65
+ RC = 12
+ XTB = 0
+ EG = 1.11
+ XTI = 3
+ CJE = 9.2E-13
+ VJE = 0.93
+ MJE = 0.355
+ CJC = 4E-13
+ VJC = 0.357
+ MJC = 0.237
+ XCJC = 0.5
+ TF = 1.2E-11
+ XTF = 500
+ VTF = 4
+ ITF = 1.2
+ PTF = 60
+ TR = 1E-09
+ FC = 0.95
.ENDS RF947
* Origin: Motbjt.lib
