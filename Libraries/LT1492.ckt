*//////////////////////////////////////////////////////////////////////////////////////
* LT1492  5MHz, 3V/µs, Low Power Single Supply, Dual Precision Operational Amplifier //
*//////////////////////////////////////////////////////////////////////////////////////
*
* connections:     non-inverting input
*                  |   inverting input
*                  |   |   positive power supply
*                  |   |   |   negative power supply
*                  |   |   |   |   output
*                  |   |   |   |   |
*                  |   |   |   |   |
.SUBCKT LT1492     1   2   3   4   5
CIN 1 2 1.0000e-011
GRIN 1 2 1 2 1.0000e-012
Q1 11 2 13 Q1
Q2 12 111 14 Q2
RC1 4 11 2.4236e+003
RC2 4 12 2.4236e+003
RE1 10 13 3.7311e+002
RE2 10 14 3.7311e+002
C1 11 12 1.3134e-011
IEE 3 10 DC 8.2607e-005
D1 10 3 DX
GA 60 99 11 12 4.1261e-004
FRI1 99 1 VRI1 1
VRI1 101 0 DC 0
RRI1 101 0 2.8980e+006
FRI2 99 2 VRI2 1
VRI2 201 0 DC 0
RRI2 201 0 2.8980e+006
GR 99 60 605 606 7.4095e-001
IR1 0 605 DC 1
IR2 0 606 DC 1
DR1 605 0 DR
DR2 606 0 DR
GCM1 99 20 POLY(2) 1 99 2 99 0 5.0000e-004 5.0000e-004
RCM1 21 99 1.000000e+003
RCM2 20 99 1.0000e+006
LCM 20 21 3.1831e-001
ECM 111 1 20 99 7.9433e-006
RP1 601 99 2.6667e+004
CP1 60 601 5.4257e-011
RP11 60 99 1.0000e+004
GP1 99 6 60 99 1.0000e-004
R2 6 99 1.0000e+003
C2 6 7 3.2742e-011
GB 7 99 6 99 2.9624e+003
R01 7 99 1.3411e+002
R02 7 50 1.0726e+002
R03 50 51 4.3117e+001
R04 51 5 1.5511e+001
R05 5 99 1.0000e+012
DOP 50 51 DOUT
DON 51 50 DOUT
VC 53 50 DC 1.6478e+000
VE 54 50 DC -1.0080e+000
DC1 53 55 DX
DC2 55 56 DX
DE1 57 54 DX
DE2 58 57 DX
GVC1 3 56 3 56 1.0E-4
GVE1 4 58 4 58 1.0E-4
GVC2 3 55 3 55 1.0E-5
GVE2 4 57 4 57 1.0E-5
GVLP 99 60 56 3 1.0000e+000
GVLN 99 60 58 4 1.0000e+000
ECLP 91 0 7 50 1.5538e-001
ECLN 92 0 7 50 1.5538e-001
DCLP 91 90 DX
DCLN 90 92 DX
VLIM 90 0 DC 0
FB 7 99 VLIM 4.8357e+000
EGND 99 0 POLY(2) 3 0 4 0 0 0.5 0.5
DSUB 4 3 DX
IP 3 4 DC 3.4239e-004
GV 31 0 7 50 9.3228e-003
DP1 3 31 DX
DP2 33 4 DX
RGV 32 33 10.0
EGV 31 32 POLY(1) 3 4 -0.85 1.0
.MODEL DX D IS=8.0000e-016 RS=0 XTI=0
.MODEL Q1 PNP IS=1.0020e-015 BF=931.7 XTB=9.2858e-001
+ XTI=3.00382e+000 KF=1.4811e-016
.MODEL Q2 PNP IS=9.9802e-016 BF=994.8 XTB=7.3963e-001
+ XTI=2.99618e+000 KF=1.4811e-016
.MODEL DR D IS=8.0000e-016 KF=3.7682e-019 RS=0 XTI=0
.MODEL DOUT D IS=1.7235e-009 RS=0 XTI=0
*
.ENDS LT1492
*
