*
* PUMD48
* 2 RETs in SC-88
* RET1 = 47kO / 47kO NPN
* PDTC144E
* RET2 = 2.2kO / 47kO PNP
* PDTA123J
*
*

.SUBCKT PUMD48 1 2 3 4 5 6
XPDTC144E 6 2 1 PDTC144E
XPDTA123J 3 5 4 PDTA123J
.ENDS

.SUBCKT PDTC144E 1 2 3
*
R1 2 21 4.7E+04
Cres1 2 1 4.8E-13
R21 21 22 2.35E+04
R22 22 3 2.35E+04
Cres2 22 1 1.5E-13
Q1 1 21 3 PDTC144E
*
.MODEL PDTC144E NPN
+ IS = 1.822E-14
+ NF = 0.9932
+ ISE = 2.894E-16
+ NE = 1.4
+ BF = 354.4
+ IKF = 0.246
+ VAF = 182
+ NR = 0.9931
+ ISC = 9.982E-12
+ NC = 1.763
+ BR = 14.99
+ IKR = 0.05
+ VAR = 17.9
+ RB = 10
+ IRB = 5E-06
+ RBM = 5
+ RE = 0.649
+ RC = 1.101
+ XTB = 0
+ EG = 1.11
+ XTI = 3
+ CJE = 1.32E-11
+ VJE = 0.8401
+ MJE = 0.3622
+ TF = 1E-32
+ XTF = 0
+ VTF = 1E+03
+ ITF = 0
+ PTF = 0
+ CJC = 3.821E-12
+ VJC = 0.5986
+ MJC = 0.3745
+ XCJC = 0.6193
+ TR = 1E-32
+ CJS = 0
+ VJS = 0.75
+ MJS = 0.333
+ FC = 0.5
.ENDS
*
.SUBCKT PDTA123J 1 2 3
*
R1 2 21 2200
Cres1 2 1 4.8E-13
R21 21 22 2.35E+04
R22 22 3 2.35E+04
Cres2 22 1 1.5E-13
Q1 1 21 3 PDTA123J
*
.MODEL PDTA123J PNP
+ IS = 2.014E-14
+ NF = 0.9974
+ ISE = 6.578E-15
+ NE = 1.45
+ BF = 339.3
+ IKF = 0.079
+ VAF = 39.15
+ NR = 0.9952
+ ISC = 1.948E-12
+ NC = 1.55
+ BR = 12.01
+ IKR = 0.015
+ VAR = 16.5
+ RB = 10
+ IRB = 5E-06
+ RBM = 5E-06
+ RE = 0.673
+ RC = 0.718
+ CJE = 1.104E-11
+ VJE = 0.9
+ MJE = 0.2748
+ TF = 1E-32
+ XTF = 0
+ VTF = 1E+03
+ ITF = 0
+ PTF = 0
+ CJC = 6.4E-12
+ VJC = 0.499
+ MJC = 0.4435
+ XCJC = 1
+ TR = 1E-32
+ CJS = 0
+ VJS = 0.75
+ MJS = 0.333
+ XTB = 0
+ XTI = 3
+ EG = 1.11
+ FC = 0.5
.ENDS
*
