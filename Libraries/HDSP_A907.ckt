*
* Diode Model Produced by Altium Ltd
* Date:  7-Apr-2004
*
* Manufacturer: Agilent
* Component Name: HDSP-A907
*
* Parameters derived from information available in data sheet.
*
*                 common-anode
*                 |  cathode-PLUS
*                 |  |  cathode-MINUS
*                 |  |  |  common-anode
*                 |  |  |  |  cathode-DP
*                 |  |  |  |  |  cathode-c
*                 |  |  |  |  |  |  cathode-b
*                 |  |  |  |  |  |  |
.SUBCKT HDSP_A907 1  2  3  6  7  8  9

DPLUS1  1  2 dHDSP_A907
DMINUS1 1  3 dHDSP_A907
DB1     1  9 dHDSP_A907
DC1     1  8 dHDSP_A907
DDP1    1  7 dHDSP_A907

DPLUS2  6  2 dHDSP_A907
DMINUS2 6  3 dHDSP_A907
DB2     6  9 dHDSP_A907
DC2     6  8 dHDSP_A907
DDP2    6  7 dHDSP_A907

.MODEL dHDSP_A907 D
+ (
+     IS = 1.37135099E-36
+      N = 0.94257009
+     RS = 17.99091536
+     BV = 30
+    IBV = 100u
+ )

.ENDS HDSP_A907
