*//////////////////////////////////////////////////////////////
* LT1195  Low Power, High-Speed Operational Amplifier        //
*//////////////////////////////////////////////////////////////
*
* connections:     non-inverting input
*                  |   inverting input
*                  |   |   positive power supply
*                  |   |   |   negative power supply
*                  |   |   |   |   output
*                  |   |   |   |   |
*                  |   |   |   |   |
.SUBCKT LT1195     3   2   7   4   6
* LT1195 FRONT END
RL1A 7 1A 500
RL2A 7 5A 500
CRL 1A 5A 6PF
RE1A 9A 10A 1200
RCM 9A 0 10MEG
I1 9A 4 DC 260UA
I2 10A 4 DC 260UA
Q1A 1A 3 9A MOD1
Q2A 5A 2 10A MOD2
.MODEL MOD1 NPN BF=500 IS=1.00E-16
.MODEL MOD2 NPN BF=550 IS=1.04E-16
*
* INPUT
RC1 7  80 7.5788E+01
RC2 7  90 7.5788E+01
Q1  80 1A  10 QM1
Q2  90 5A  11 QM2
CIN 2  3  2.000E-12
C1  80 90 20.981E-12

*RE1 10 12 +6.8885E+01
*RE2 11 12 +6.8885E+01
*jg, 29/6/2000: syntax corrected

RE1 10 12 6.8885E+01
RE2 11 12 6.8885E+01

IEE 12 4  7.5010E-03
RE  12 0  2.6663E+04
* INTERMEDIATE
GCM 0  8  12 0  7.4199E-07
GA  8  0  80 90 1.3195E-02
R2  8  0  1.0000E+05
C2  1  800  2.0000E-11
RXC2 800 8 800
GB  1  0  8  0  6.3148E-01
RO2 1  0  9.0000E+00
* OUTPUT
RSO 1  6  1.0000E+00
ECL 18 0  1  6  2.8915E+01
GCL 0  8  20 0  1.0000E+00
RCL 20 0  1.0000E+01
D1  18 19 DM1
VOD1 19 20 0.0000E+00
D2  20 21 DM1
VOD2 21 18 0.0000E+00
*
D3A 131 70 DM3
D3B 13 131 DM3
GPL 0  8  70 7  1.0000E+00
VC  13 6  2.5586E+00
RPLA 7  70 1.0000E+01
RPLB 7  131 1.0000E+03
D4A 60 141 DM3
D4B 141 14  DM3
GNL 0  8  60 4  1.0000E+00
VE  6  14 2.0586E+00
RNLA 60 4  1.0000E+01
RNLB 141 4  1.0000E+03
*
IP  7  4  4.4990E-03
DSUB 4  7  DM2
* MODELS
.MODEL QM1 NPN (IS=8.0000E-16 BF=6.2500E+03)
.MODEL QM2 NPN (IS=8.9844E-16 BF=9.3750E+03)
.MODEL DM1  D   (IS=1.0000E-20)
.MODEL DM2  D   (IS=8.0000E-16 BV=2.1600E+01)
.MODEL DM3  D   (IS=1.0000E-16)
.ENDS LT1195
