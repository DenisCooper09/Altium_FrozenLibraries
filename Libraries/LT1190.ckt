*//////////////////////////////////////////////////
* LT1190  Ultra High-Speed Operational Amplifier //
*//////////////////////////////////////////////////
*
* connections:     non-inverting input
*                  |   inverting input
*                  |   |   positive power supply
*                  |   |   |   negative power supply
*                  |   |   |   |   output
*                  |   |   |   |   |
*                  |   |   |   |   |
.SUBCKT LT1190     3   2   7   4   6
* INPUT
RC1 7  80 9.6458E+01
RC2 7  90 9.6458E+01
Q1  80 2  10 QM1
Q2  90 3  11 QM2
CIN 2  3  2.2000E-12
C1  80 90 4.0192E-12
*
CXC1 80 80A 10PF
RXR1 80A 90 500
*
*RE1 10 12 +9.3801E+01
*RE2 11 12 +9.3801E+01
*jg, 28/6/2000: syntax corrected

RE1 10 12 9.3801E+01
RE2 11 12 9.3801E+01

IEE 12 4  1.9501E-02
RE  12 0  1.0256E+04
* INTERMEDIATE
GCM 0  8  12 0  3.2784E-06
GA  8  0  80 90 1.0367E-02
R2  8  0  1.0000E+05
C2  1  8  3.0000E-11
GB  1  0  8  0  6.4305E+00
RO2 1  0  1.5000E+00
* OUTPUT
RSO 1  6  1.0000E+00
ECL 18 0  1  6  1.2338E+01
GCL 0  8  20 0  1.0000E+00
RCL 20 0  1.0000E+01
D1  18 19 DM1
VOD1 19 20 0.0000E+00
D2  20 21 DM1
VOD2 21 18 1.8507E-01
*
D3A 131 70 DM3
D3B 13 131 DM3
GPL 0  8  70 7  1.0000E+00
VC  13 6  2.6107E+00
RPLA 7  70 1.0000E+01
RPLB 7  131 1.0000E+03
D4A 60 141 DM3
D4B 141 14  DM3
GNL 0  8  60 4  1.0000E+00
VE  6  14 2.1107E+00
RNLA 60 4  1.0000E+01
RNLB 141 4  1.0000E+03
*
IP  7  4  1.2499E-02
DSUB 4  7  DM2
* MODELS
.MODEL QM1 NPN (IS=8.0000E-16 BF=1.6250E+04)
.MODEL QM2 NPN (IS=8.9844E-16 BF=2.4375E+04)
.MODEL DM1  D   (IS=1.0000E-20)
.MODEL DM2  D   (IS=8.0000E-16 BV=2.1600E+01)
.MODEL DM3  D   (IS=1.0000E-16)
.ENDS LT1190
