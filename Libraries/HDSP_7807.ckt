*
* Diode Model Produced by Altium Ltd
* Date:  3-May-2004
*
* Manufacturer: Renesas
* Component Name: HDSP-7807
*
* Parameters derived from information available in data sheet.
*
*                 common-anode
*                 |  cathode-PLUS
*                 |  |  cathode-MINUS
*                 |  |  |  common-anode
*                 |  |  |  |  cathode-DP
*                 |  |  |  |  |  cathode-c
*                 |  |  |  |  |  |  cathode-b
*                 |  |  |  |  |  |  |
.SUBCKT HDSP_7807 1  2  3  6  7  8  9

DPLUS1  1  2  dHDSP_7807
DMINUS1 1  3  dHDSP_7807
DB1     1  9  dHDSP_7807
DC1     1  8  dHDSP_7807
DDP1    1  7  dHDSP_7807

DPLUS2  6  2  dHDSP_7807
DMINUS2 6  3  dHDSP_7807
DB2     6  9  dHDSP_7807
DC2     6  8  dHDSP_7807
DDP2    6  7  dHDSP_7807

.MODEL dHDSP_7807 D
+ (
+     IS = 1.61114016E-27
+      N = 1.30291189
+     RS = 12.83456794
+     BV = 50
+    IBV = 100u
+ )

.ENDS HDSP_7807
