*///////////////////////////////////////////////////////////////
* LT1468  90MHz, 22V/µs 16-Bit Accurate Operational Amplifier //
*///////////////////////////////////////////////////////////////
*
* connections:     non-inverting input
*                  |   inverting input
*                  |   |   positive power supply
*                  |   |   |   negative power supply
*                  |   |   |   |   output
*                  |   |   |   |   |
*                  |   |   |   |   |
.SUBCKT LT1468     3   2   7   4   6
* input
rc1 4  80 277
rc2 4  90 277
q1  80 102 10 qm1
q2  90 103 11 qm2
cinm 2  0  4.0E-12
cinp 3  0  4.0E-12
rb1  2   102 1.0000E+02
rb2  3   103 1.0000E+02
ddm1 102 103 dm2
ddm2 103 102 dm2
*input pole at 600MHz
c1  80 90 0.479E-12
re1 10 12 -44
re2 11 12 -44
iee 7  12 1.6055E-04
*assymetrical slewing
gosit 7  12 90  80  488E-06
re  12 0  1.2457E+06
* intermediate
gcm 8  0  12 0  5.56E-08
ga  8  0  78 0  3.56E-03
r2  8  0  286E+06
c2  8  0  6.3E-12
dc1 8  7  dm3
dc2 4  8  dm3
*pole at 60MHz
gx1 0  28 90 80 1E-06
rx1 28 0  1E+06
cx1 28 0  2.65E-15
*pole at 2MHz
gx2 0  38 28 0  1E-06
rx2 38 0  1E+06
cx2 38 0  79.6E-15
*zero at 8MHz
gx3 0  48 38 0  1E-06
rx3 48 49 1E+06
lx3 49 0  19.9E-03
*zero at 80MHz
gx4 0  58 48 0  1E-06
rx4 58 59 1E+06
lx4 59 0  1.99E-03
*pole at 160MHz
gx5 0  68 58 0  1E-06
rx5 68 0 1E+06
cx5 68 0 0.995E-15
*pole at 80MHz
gx6 0  78 68 0  1E-06
rx6 78 0  1E+06
cx6 78 0  1.99E-15
*output
eb  1  0  8  0  1
ro2 1  6  1.7000E+01
* current limit
ecl 18 1  6  1  .99
q3 7 18 8 qm3
q4 4 18 8 qm4
*
d3a 131 70 dm3
d3b 13 131 dm3
gpl 8  0  70 7  1.0000E+00
vc  13 6  2.3312E+00
rpla 7  70 1.0000E+01
rplb 7  131 1.0000E+03
d4a 60 141 dm3
d4b 141 14  dm3
gnl 8  0  60 4  1.0000E+00
ve  6  14 2.9312E+00
rnla 60 4  1.0000E+01
rnlb 141 4  1.0000E+03
*
ip  7  4  3.7394E-03
dsub 4  7  dm2
* models
.model qm1 pnp (is=8.0000E-16 bf=8.0E+03)
.model qm2 pnp (is=8.0206E-16 bf=2.0E+03)
.model qm3 npn (is=8.0000E-16 bf=100)
.model qm4 pnp (is=8.0000E-16 bf=100)
.model dm1  d   (is=1.0000E-20)
.model dm2  d   (is=8.0000E-16 bv=4.3200E+01)
.model dm3  d   (is=1.0000E-16)
.ENDS LT1468
*
