* INA115 = 2 x A1_115 + A3_115 OP AMPS + PRECISION RESISTOR NETWORK

* CREATED ON 1/10/94 BY JLA

* REV.A

* NODE ASSIGNMENTS OF SUBCKT INA115 CORRESPOND TO SURFACE MOUNT PACKAGE OF

* BURR-BROWN'S INA115 (NO DIP AVAILABLE)

*

*  ------------------------------------------------------------------------

* |  NOTICE: THE INFORMATION PROVIDED HEREIN IS BELIEVED TO BE RELIABLE;   |

* |  HOWEVER; BURR-BROWN ASSUMES NO RESPONSIBILITY FOR INACCURACIES OR     |

* |  OMISSIONS.  BURR-BROWN ASSUMES NO RESPONSIBILITY FOR THE USE OF THIS  |

* |  INFORMATION, AND ALL USE OF SUCH INFORMATION SHALL BE ENTIRELY AT     |

* |  THE USER'S OWN RISK.  NO PATENT RIGHTS OR LICENSES TO ANY OF THE      |

* |  CIRCUITS DESCRIBED HEREIN ARE IMPLIED OR GRANTED TO ANY THIRD PARTY.  |

* |  BURR-BROWN DOES NOT AUTHORIZE OR WARRANT ANY BURR-BROWN PRODUCT FOR   |

* |  USE IN LIFE-SUPPORT DEVICES AND/OR SYSTEMS.                           |

*  ------------------------------------------------------------------------

*

* NOTE:  THE OUTPUT PERFORMANCE OF THE MACRO MODEL WILL BE ERRONEOUS IF

*        NODE 12 (FEEDBACK) IS NOT CONNECTED PROPERLY.  THIS IS GENERALLY

*        CONNECTED TO NODE 11 (OUTPUT).

*

*

***** INA115 SUB-CIRCUIT

* CONNECTIONS:    NON-INVERTING INPUT

*                 |   INVERTING INPUT

*                 |   |   POSITIVE POWER SUPPLY

*                 |   |   |   NEGATIVE POWER SUPPLY

*                 |   |   |   |   OUTPUT

*                 |   |   |   |   |   FEEDBACK

*                 |   |   |   |   |   |    REFERENCE

*                 |   |   |   |   |   |    |   GAIN SET 1

*                 |   |   |   |   |   |    |   |   GAIN SET 2

*                 |   |   |   |   |   |    |   |   |   GAIN SENSE 1

*                 |   |   |   |   |   |    |   |   |   |   GAIN SENSE 2

*                 |   |   |   |   |   |    |   |   |   |   |

.SUBCKT INA115    5   4   13  7   11  12   10  3   14  2   15

*

***** A1_115 SUBCIRCUIT

* CONNECTIONS:    NON-INVERTING INPUT

*                 |   INVERTING INPUT

*                 |   |   POSITIVE POWER SUPPLY

*                 |   |   |   NEGATIVE POWER SUPPLY

*                 |   |   |   |   OUTPUT

*                 |   |   |   |   |

X1                4   2   13  7   1   A1_115

*

* CONNECTIONS:    NON-INVERTING INPUT

*                 |   INVERTING INPUT

*                 |   |   POSITIVE POWER SUPPLY

*                 |   |   |   NEGATIVE POWER SUPPLY

*                 |   |   |   |   OUTPUT

*                 |   |   |   |   |

X2                5   15  13  7   8   A1_115

*

* CONNECTIONS:    NON-INVERTING INPUT

*                 |   INVERTING INPUT

*                 |   |   POSITIVE POWER SUPPLY

*                 |   |   |   NEGATIVE POWER SUPPLY

*                 |   |   |   |   OUTPUT

*                 |   |   |   |   |

X3                17  18  13  7   11   A3_115

*

RFB1 1 3 25K

RFB2 8 14 25K

R1 1 18 25K

R2 18 12 24.9985K

R3 8 17 25K

R4 17 10 25K

C1 17 10 5P

C2 18 12 5P

CC1 1 3 5P

CC2 8 14 5P

*

.ENDS

*

* A1_115 OPERATIONAL AMPLIFIER " MACROMODEL" SUBCIRCUIT

* CREATED USING PARTS RELEASE 5.0 ON 1/22/92 AT 13:21

*

* CONNECTIONS:   NON-INVERTING INPUT

*                |   INVERTING INPUT

*                |   |   POSITIVE POWER SUPPLY

*                |   |   |   NEGATIVE POWER SUPPLY

*                |   |   |   |   OUTPUT

*                |   |   |   |   |

.SUBCKT A1_115   1   2   3   4   5

*

C1 11 12 6.060E-12

C2 6 7 30.00E-12

DC 5 53 DX

DE 54 5 DX

DLP 90 91 DX

DLN 92 90 DX

DP 4 3 DX

EGND 99 0 POLY(2) (3,0) (4,0) 0 .5 .5

FB 7 99 POLY(5) VB VC VE VLP VLN 0 165.8E6 -20E6 20E6 20E6 -20E6

GA 6 0 11 12 188.5E-6

GCM 0 6 10 99 188.5E-12

IEE 10 4 DC 27E-6

HLIM 90 0 VLIM 1K

Q1 11 2 13 QX

Q2 12 1 14 QX

R2 6 9 100.0E3

RC1 3 11 5.305E3

RC2 3 12 5.305E3

RE1 13 10 4.348E3

RE2 14 10 4.348E3

REE 10 99 7.4074E6

RO1 8 5 40

RO2 7 99 320

RP 3 4 52.53E3

VB 9 0 DC 0

VC 3 53 DC 1.672

VE 54 4 DC 1.672

VLIM 7 8 DC 0

VLP 91 0 DC 2

VLN 0 92 DC 2

.MODEL DX D(IS=800.0E-18)

.MODEL QX NPN(IS=800.0E-18 BF=36.00E3 NC=100 NR=100)

.ENDS

*

*

* A3_115 OPERATIONAL AMPLIFIER " MACROMODEL" SUBCIRCUIT

* CREATED USING PARTS RELEASE 5.0 ON 1/22/92 AT 13:46

*

* CONNECTIONS:   NON-INVERTING INPUT

*                | INVERTING INPUT

*                | | POSITIVE POWER SUPPLY

*                | | | NEGATIVE POWER SUPPLY

*                | | | | OUTPUT

*                | | | | |

.SUBCKT A3_115  1 2 3 4 5

*

C1 11 12 13.51E-12

C2 6 7 30.00E-12

DC 5 53 DX

DE 54 5 DX

DLP 90 91 DX

DLN 92 90 DX

DP 4 3 DX

EGND 99 0 POLY(2) (3,0) (4,0) 0 .5 .5

FB 7 99 POLY(5) VB VC VE VLP VLN 0 251.9E6 -30E6 30E6 30E6 -30E6

GA 6 0 11 12 339.3E-6

GCM 0 6 10 99 339.3E-12

IEE 10 4 DC 18E-6

HLIM 90 0 VLIM 1K

Q1 11 2 13 QX

Q2 12 1 14 QX

R2 6 9 100.0E3

RC1 3 11 2.947E3

RC2 3 12 2.947E3

RE1 13 10 74.778

RE2 14 10 74.778

REE 10 99 11.111E6

RO1 8 5 13

RO2 7 99 117

RP 3 4 30.123E3

VB 9 0 DC 0

VC 3 53 DC 1.972

VE 54 4 DC 1.972

VLIM 7 8 DC 0

VLP 91 0 DC 12

VLN 0 92 DC 12

.MODEL DX D(IS=800.0E-18)

.MODEL QX NPN(IS=800.0E-18 BF=30.00E3)

.ENDS


