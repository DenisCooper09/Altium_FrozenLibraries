*D44H8 MCE 4/8/97
*Si 60W 60V 8A 50MHz PwrAmp pkg:TO-220 2,1,3
.SUBCKT D44H8    1 2 3
*    TERMINALS:  C B E
Q1 1 2 3  QPWR .67
Q2 1 4 3  QPWR .33
RBS  2 4  30.5
.MODEL QPWR NPN (IS=590F NF=1 BF=131 VAF=139 IKF=2.67 ISE=395P NE=2
+ BR=4 NR=1 VAR=20 IKR=4 RE=41.4M RB=0.166 RC=16.6M XTB=1.5
+ CJE=1.28N VJE=0.6 MJE=0.3 CJC=245P VJC=0.22 MJC=0.2 TF=3.18N TR=122N)
.ENDS
