*BZX85C6V8 MCE 4/7/98
*Ref: Temic Semiconductor Short Form, 1996
*6.8V 1300mW Si Zener pkg:Diode0.4 1,2
.SUBCKT BZX85C6V8 1 2
*    TERMINALS:  A K
D1 1 2  DF
DZ 3 1  DR
VZ 2 3  6.294
.MODEL DF D (IS=6.53N RS=32.3M N=1.7 CJO=160P VJ=0.75 M=0.33 TT=50.1N)
.MODEL DR D (IS=9.83E-18 RS=0.171 N=0.54)
.ENDS
