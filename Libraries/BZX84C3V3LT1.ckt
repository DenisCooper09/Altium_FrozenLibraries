*BZX84C3V3LT1 MCE 6/20/97
*Ref: Motorola TVS/Zener Databook, Q2/94
*3.3V 1000mW Si Zener pkg:SOT-23 1,3
.SUBCKT BZX84C3V3LT1 1 2
*    TERMINALS:  A K
D1 1 2  DF
DZ 3 1  DR
VZ 2 3  2.591
.MODEL DF D (IS=5.02N RS=42M N=1.7 CJO=450P VJ=0.75 M=0.33 TT=50.1N)
.MODEL DR D (IS=1.11M RS=28.5 N=13)
.ENDS
* Origin: Mcediode.lib
