* BEGIN MODEL LMP2232
* Rev.b. 01/2009
* Corrected .subckt and pins line PG 1/20/2009
*//////////////////////////////////////////////////////////////////////
* (C) National Semiconductor, Corporation.
* Models developed and under copyright by:
* National Semiconductor, Corporation.
*/////////////////////////////////////////////////////////////////////
* Legal Notice:
* The model may be copied, and distributed without any modifications;
* however, reselling or licensing the material is illegal.
* We reserve the right to make changes to the model without prior notice.
* PSPICE Models are provided "AS IS, WITH NO WARRANTY OF ANY KIND"
*////////////////////////////////////////////////////////////////////
* MODEL FEATURES INCLUDE OUTPUT SWING, OUTPUT CURRENT THRU
* THE SUPPLY RAILS, OUTPUT CURRENT LIMIT, OPEN LOOP GAIN
* AND PHASE WITH RL AND CL EFFECTS, SLEW RATE, COMMON MODE
* REJECTION WITH FREQ EFFECTS, POWER SUPPLY REJECTION WITH
* FREQ EFFECTS, INPUT VOLTAGE NOISE WITH 1/F, INPUT CURRENT
* NOISE, INPUT BIAS CURRENT, INPUT BIAS CURRENT TEMPERATURE
* EFFECTS, INPUT COMMON MODE RANGE, INPUT OFFSET VOLTAGE
* WITH TEMPERATURE EFFECTS, AND QUIESCENT CURRENT VS
* VOLTAGE AND TEMPERATURE.
* NOTE THAT SUPPLY CURRENT MODELED IS THAT OF A SINGLE AMPLIFIER ONLY
*///////////////////////////////////////////////////////////////////
* PINOUT ORDER +IN -IN +V -V OUT
*
.SUBCKT LMP2232 3 4 5 2 1
*/////////////////////////////////////////////////////////////////////
* USE V18 BELOW TO ADJUST OFFSET
* PRESENT VALUE OF 110 UV GIVES 150 UV NET
* NOTE THAT VOS CHANGES VIA CMRR,PSRR, AND TCVOS
* ADJUST UP OR DN FROM 110 UV
V18 23 52 110U
*/////////////////////////////////////////////////////////////////////
* NOTE
* USE ANALYSIS OPTION GMIN OF 1E-13 TO 1E-15 AND
* RELTOL = 0.00001 TO 0.000001 FOR ACCURATE INPUT
* BIAS CURRENT
*/////////////////////////////////////////////////////////////////////
Q20 6 7 8 QNL
R3 9 10 2
R4 11 10 2
R10 7 12 100
R11 13 14 100
R12 14 5 25
R13 2 12 32
R17 15 16 25
R18 8 17 32
D5 1 5 DD
D6 2 1 DD
D7 18 0 DIN
D8 19 0 DIN
I8 0 18 0.1E-3
I9 0 19 0.1E-3
E2 8 0 2 0 1
E3 16 0 5 0 1
D9 20 0 DVN
D10 21 0 DVN
I10 0 20 0.2E-6
I11 0 21 0.2E-6
E4 22 4 20 21 0.326
G2 23 4 18 19 4.8E-6
E5 24 0 16 0 1
E6 25 0 8 0 1
E7 26 0 27 0 1
R30 24 28 1E6
R31 25 29 1E6
R32 26 30 1E6
R33 0 28 100
R34 0 29 100
R35 0 30 100
E10 31 32 30 0 3.4E-3
R36 33 27 1E3
R37 27 34 1E3
C6 24 28 0.2E-12
C7 25 29 0.2E-12
C8 26 30 2E-12
E11 35 31 29 0 1E-3
E12 23 35 28 0 1E-2
E14 36 8 16 8 0.51
D11 37 16 DD
D12 8 37 DD
M1 38 39 12 12 HVN L=3U W=500U
M2 40 41 14 14 HVP L=3U W=600U
M3 42 42 15 15 HVP L=3U W=600U
M4 43 44 9 9 HVP L=3U W=5.5U
M5 45 46 11 11 HVP L=3U W=5.5U
M8 47 47 17 17 HVN L=3U W=500U
R43 48 41 100
R44 49 39 100
G3 37 36 50 36 2E-6
R45 36 37 1.5E11
R46 8 43 2E5
R47 8 45 2E5
C13 43 45 0.2E-12
C14 23 0 6E-12
C15 22 0 6E-12
C16 1 0 3E-12
D13 39 6 DD
D14 51 41 DD
Q15 51 13 16 QPL
M19 53 54 16 16 PIN L=6U W=500U
I14 42 47 1.7E-7
E17 34 0 23 0 1
E18 33 0 4 0 1
M23 54 54 16 16 PIN L=6U W=500U
V21 53 10 0.01
R59 1 40 33
R60 38 1 33
J1 16 23 16 JC
J2 16 22 16 JC
J3 22 55 22 JC
J4 23 55 23 JC
C21 23 22 0.1E-12
E20 56 36 45 43 1
R62 56 50 1E4
C23 50 36 1E-12
G7 57 36 37 36 -1E-3
G8 36 58 37 36 1E-3
G9 36 59 47 8 1E-3
G10 60 36 16 42 1E-3
D17 60 57 DD
D18 58 59 DD
R66 57 60 1E11
R67 59 58 1E11
R68 60 16 1E3
R69 8 59 1E3
E23 16 48 16 60 1
E24 49 8 59 8 1
R70 58 36 1E11
R71 59 36 1E11
R72 36 60 1E11
R73 36 57 1E11
C27 41 40 70E-15
C28 38 39 70E-15
R74 2 5 2.31E6
G12 5 2 61 0 -1.03E-6
I20 0 62 1M
D20 62 0 DD
V24 62 61 0.71
R75 0 61 1E6
I21 5 2 7.23E-6
E25 63 0 1 0 1
C29 37 64 6.5E-12
R79 64 63 5E3
R80 37 63 1E12
V52 65 0 1
I63 0 66 1E-3
D23 66 0 DD
R307 0 66 10E6
V81 66 67 1.798
R308 0 67 20E6
E52 68 0 67 0 -0.875
R309 0 68 10E6
R310 69 68 10E6
M52 69 70 0 0 NEN L=2U W=1000U
V141 71 0 1
R311 71 70 1E6
M53 70 65 0 0 NEN L=2U W=100U
R312 0 67 20E6
G14 54 8 69 0 0.93E-6
D24 72 73 DL
V142 73 0 3
R313 0 72 1E8
G51 4 0 72 0 3.55E-12
I64 4 0 76E-15
G52 23 0 72 0 3.55E-12
I65 23 0 76E-15
E54 32 3 69 0 2.58E-4
R315 46 22 4.8E4
R316 52 44 4.8E4
R317 35 23 1E9
R318 31 35 1E9
R319 32 31 1E9
R320 4 22 1E9
V143 55 8 0.11
.MODEL JC NJF IS=1E-18
.MODEL QNL NPN
.MODEL QPL PNP
.MODEL DVN D KF=1.05E-16 IS=1E-16
.MODEL DIN D
.MODEL HVP PMOS KP=200U VTO=-0.7
.MODEL HVN NMOS KP=200U VTO=0.7
.MODEL DL D IS=0.95E-11 N=1.47 XTI=1.5
.MODEL DD D
.MODEL PIN PMOS KP=200U VTO=-0.7
.MODEL NEN NMOS KP=200U VTO=0.5 IS=1E-18
.ENDS
* END MODEL LMP2232
