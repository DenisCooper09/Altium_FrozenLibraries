*
* Diode Model Produced by Altium Ltd
* Date:  5-Apr-2004
*
* Manufacturer: Agilent
* Component Name: HDSP-B03G
*
* Parameters derived from information available in data sheet.
*
*                 anode-e
*                 |  anode-d
*                 |  |  anode-DP
*                 |  |  |  anode-c
*                 |  |  |  |  anode-g
*                 |  |  |  |  |  common-cathode-K4
*                 |  |  |  |  |  |  anode-b
*                 |  |  |  |  |  |  |  common-cathode-K3
*                 |  |  |  |  |  |  |  |  common-cathode-K2
*                 |  |  |  |  |  |  |  |  |  anode-f
*                 |  |  |  |  |  |  |  |  |  |  anode-a
*                 |  |  |  |  |  |  |  |  |  |  |  common-cathode-K1
*                 |  |  |  |  |  |  |  |  |  |  |  |
.SUBCKT HDSP_B03G 1  2  3  4  5  6  7  8  9  10 11 12

DA1  11 12  dHDSP_B03G
DB1   7 12  dHDSP_B03G
DC1   4 12  dHDSP_B03G
DD1   2 12  dHDSP_B03G
DE1   1 12  dHDSP_B03G
DF1  10 12  dHDSP_B03G
DG1   5 12  dHDSP_B03G

DA2  11  9  dHDSP_B03G
DB2   7  9  dHDSP_B03G
DC2   4  9  dHDSP_B03G
DD2   2  9  dHDSP_B03G
DE2   1  9  dHDSP_B03G
DF2  10  9  dHDSP_B03G
DG2   5  9  dHDSP_B03G
DDP2  3  9  dHDSP_B03G

DA3  11  8  dHDSP_B03G
DB3   7  8  dHDSP_B03G
DC3   4  8  dHDSP_B03G
DD3   2  8  dHDSP_B03G
DE3   1  8  dHDSP_B03G
DF3  10  8  dHDSP_B03G
DG3   5  8  dHDSP_B03G
DDP3  3  8  dHDSP_B03G

DA4  11  6  dHDSP_B03G
DB4   7  6  dHDSP_B03G
DC4   4  6  dHDSP_B03G
DD4   2  6  dHDSP_B03G
DE4   1  6  dHDSP_B03G
DF4  10  6  dHDSP_B03G
DG4   5  6  dHDSP_B03G

.MODEL dHDSP_B03G D
+ (
+     IS = 3.48036841E-22
+      N = 1.64316142
+     RS = 13.66953373
+     BV = 4.8
+    IBV = 100u
+ )

.ENDS HDSP_B03G
