*MPQ6426 MCE 6/19/97
*Ref: Motorola Small-Signal Device Databook, Q4/94
*Si 500mW 30V 500mA Quad pkg:DIP14 (A:1,2,3)(B:7,6,5)(C:8,9,10)(D:14,13,12)
.SUBCKT MPQ6426  1 2 3
*    TERMINALS:  C B E
Q1 1 2 4 QPWR .1
Q2 1 4 3 QPWR
.MODEL QPWR PNP (IS=600F NF=1 BF=100 VAF=98.6 IKF=0.4 ISE=49P NE=2
+ BR=4 NR=1 VAR=48 IKR=0.6 RE=1.5 RB=6 RC=0.6 CJE=115P XTB=1.5
+ VJE=0.74 MJE=0.45 CJC=16.5P VJC=1.1 MJC=0.24 TF=60.3N TR=2.61U)
.ENDS
* Origin: Mcebjt.lib
