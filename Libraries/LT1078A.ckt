*/////////////////////////////////////////////////////////////////////////////
* LT1078A  Micropower, Dual, Single Supply, Precision Operational Amplifier //
*/////////////////////////////////////////////////////////////////////////////
*
* connections:     non-inverting input
*                  |   inverting input
*                  |   |   positive power supply
*                  |   |   |   negative power supply
*                  |   |   |   |   output
*                  |   |   |   |   |
*                  |   |   |   |   |
.SUBCKT LT1078A    3   2   7   4   6
* INPUT
RC1 4 80 2.653E+04
RC2 4 90 2.653E+04
Q1 80 102 10 QM1
Q2 90 103 11 QM2
RB1 2 102 6.000E+02
RB2 3 103 6.000E+02
DCM1 105 102 DM2
DCM2 105 103 DM2
VCMC 105 4 4.000E-01
C1 80 90 8.660E-12
RE1 10 12 4.958E+03
RE2 11 12 4.958E+03
IEE 7 12 2.412E-06
RE 12 0 8.292E+07
CE 12 0 1.579E-12
* INTERMEDIATE
GCM 0 8 12 0 1.501E-10
GA 8 0 80 90 3.770E-05
R2 8 0 1.000E+05
C2 1 8 3.000E-11
GB 1 0 8 0 2.449E+02
* OUTPUT
RO1 1 110 1.000E+02
RO2A 1 0 1.083E+03
RO2B 6 110 8.170E+02
EC 17 0 110 0 1
D1 1 17 DM1
D2 17 1 DM1
D3 110 13 DM2
D4 14 110 DM2
D5 6 110 DM2
D6 110 6 DM2
VC 7 13 1.490E+00
VE 14 4 7.911E-01
IP 7 4 4.259E-05
DSUB 4 7 DM2
* MODELS
.MODEL QM1 PNP (IS=8.000E-16 BF=1.992E+02)
.MODEL QM2 PNP (IS=8.009E-16 BF=2.008E+02)
.MODEL DM1 D (IS=3.718E-24)
.MODEL DM2 D (IS=8.000E-16)
.ENDS LT1078A
