* UAF42 OPERATIONAL AMPLIFIER "MACROMODEL" SUBCIRCUIT

* SUBCIRCUIT AMP_UAF CREATED USING PARTS RELEASE 4.03 ON 10/17/90 AT 14:54

*

* UAF42 = 4x AMP_UAF + PRECISION RESISTORS AND CAPS

*

* REV. B  1/3/94/JA CHANGED THE ENTIRE MACRO MODEL FILE TO BE A UAF42

*                   INSTEAD OF A SINGLE OP AMP CONTAINED IN THE UAF42.

*                   NODE ASSIGNMENTS OF SUBCKT UAF42 ARE THE SAME AS THE DIP

*                   PACKAGE UAF42 PINOUT.

*

*  ------------------------------------------------------------------------

* |  NOTICE: THE INFORMATION PROVIDED HEREIN IS BELIEVED TO BE RELIABLE;   |

* |  HOWEVER; BURR-BROWN ASSUMES NO RESPONSIBILITY FOR INACCURACIES OR     |

* |  OMISSIONS.  BURR-BROWN ASSUMES NO RESPONSIBILITY FOR THE USE OF THIS  |

* |  INFORMATION, AND ALL USE OF SUCH INFORMATION SHALL BE ENTIRELY AT     |

* |  THE USER'S OWN RISK.  NO PATENT RIGHTS OR LICENSES TO ANY OF THE      |

* |  CIRCUITS DESCRIBED HEREIN ARE IMPLIED OR GRANTED TO ANY THIRD PARTY.  |

* |  BURR-BROWN DOES NOT AUTHORIZE OR WARRANT ANY BURR-BROWN PRODUCT FOR   |

* |  USE IN LIFE-SUPPORT DEVICES AND/OR SYSTEMS.                           |

*  ------------------------------------------------------------------------

*

***** UAF42 SUB-CIRCUIT

* CONNECTIONS:   LOW-PASS OUTPUT

*                | V IN 3

*                | | V IN 2

*                | | | AUX AMP NON-INVERTING INPUT

*                | | | | AUX AMP INVERTING INPUT

*                | | | | | AUX AMP OUTPUT

*                | | | | | | BAND-PASS OUTPUT

*                | | | | | | | FREQUENCY ADJ1

*                | | | | | | | | NEGATIVE POWER SUPPLY

*                | | | | | | | | | POSITIVE POWER SUPPLY

*                | | | | | | | | | |  GROUND

*                | | | | | | | | | |  |  V IN 1

*                | | | | | | | | | |  |  |  HIGH-PASS OUTPUT

*                | | | | | | | | | |  |  |  |  FREQUENCY ADJ2

*                | | | | | | | | | |  |  |  |  |

.SUBCKT UAF42    1 2 3 4 5 6 7 8 9 10 11 12 13 14

*

* CONNECTIONS:   NON-INVERTING INPUT

*                | INVERTING INPUT

*                | |  POSITIVE POWER SUPPLY

*                | |  |  NEGATIVE POWER SUPPLY

*                | |  |  | OUTPUT

*                | |  |  | |

X1               3 12 10 9 13   AMP_UAF

*

* CONNECTIONS:   NON-INVERTING INPUT

*                |  INVERTING INPUT

*                |  | POSITIVE POWER SUPPLY

*                |  | |  NEGATIVE POWER SUPPLY

*                |  | |  | OUTPUT

*                |  | |  | |

X2               11 8 10 9 7   AMP_UAF

*

* CONNECTIONS:   NON-INVERTING INPUT

*                |  INVERTING INPUT

*                |  |  POSITIVE POWER SUPPLY

*                |  |  |  NEGATIVE POWER SUPPLY

*                |  |  |  | OUTPUT

*                |  |  |  | |

X3               11 14 10 9 1   AMP_UAF

*

*

* CONNECTIONS:   NON-INVERTING INPUT

*                | INVERTING INPUT

*                | | POSITIVE POWER SUPPLY

*                | | |  NEGATIVE POWER SUPPLY

*                | | |  | OUTPUT

*                | | |  | |

X4               4 5 10 9 6   AMP_UAF

*

R1 12 1 50K

R2 12 13 50K

R4 3 7 50K

R3A 3 2 100K

R3B 3 2 100K

C1 7 8 1000P

C2 1 14 1000P

C3 13 14 1P

*

.ENDS

*

* AMP_UAF OPERATIONAL AMPLIFIER "MACROMODEL" SUBCIRCUIT

*

* CONNECTIONS:   NON-INVERTING INPUT

*                | INVERTING INPUT

*                | | POSITIVE POWER SUPPLY

*                | | | NEGATIVE POWER SUPPLY

*                | | | | OUTPUT

*                | | | | |

.SUBCKT AMP_UAF  1 2 3 4 5

*

C1   11 12 8.938E-12

C2    6  7 15.00E-12

CSS  10 99 8.077E-12

DC    5 53 DX

DE   54  5 DX

DLP  90 91 DX

DLN  92 90 DX

DP    4  3 DX

EGND 99  0 POLY(2) (3,0) (4,0) 0 .5 .5

FB    7 99 POLY(5) VB VC VE VLP VLN 0 99.42E6 -10E6 10E6 10E6 -10E6

GA    6  0 11 12 424.1E-6

GCM   0  6 10 99 6.722E-9

ISS   3 10 DC 300.0E-6

HLIM 90  0 VLIM 1K

J1   11  2 10 JX

J2   12  1 10 JX

G11 2 4 POLY(3) (10,2) (11,2) (4,2) 0 1E-12 1E-12 1E-12

G21 1 4 POLY(3) (10,1) (12,1) (4,1) 0 1E-12 1E-12 1E-12

R2    6  9 100.0E3

RD1   4 11 2.358E3

RD2   4 12 2.358E3

RO1   8  5 75

RO2   7 99 75

RP    3  4 20.00E3

RSS  10 99 666.7E3

VB    9  0 DC 0

VC    3 53 DC 3.500

VE   54  4 DC 3.500

VLIM  7  8 DC 0

VLP  91  0 DC 25

VLN   0 92 DC 25

.MODEL DX D(IS=800.0E-18)

.MODEL JX PJF(IS=5.000E-12 BETA=299.8E-6 VTO=-1)

.ENDS


