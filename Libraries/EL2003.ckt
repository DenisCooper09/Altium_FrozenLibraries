*EL2003 Macromodel
* Connections:         +input
*                      |   output
*                      |   |   +Vsupply
*                      |   |   |   -Vsupply
*                      |   |   |   |
.subckt EL2003         2   7   1   4
*
* Input Stage
*
e1 10 0 2 0 1.0
r1 10 0 1K
rh 10 11 150
ch 11 0 10pF
rc 11 12 100
cc 12 0 3pF
e2 13 0 12 0 1.0
*
* Output Stage
*
q1 4 13 14 qp
q2 1 13 15 qn
q3 1 14 16 qn
q4 4 15 19 qp
r2 16 7 5
r3 19 7 5
c1 14 0 3pF
c2 15 0 3pF
i1 1 14 3mA
i2 15 4 3mA
*
* Bias Current
*
iin+ 2 0 5uA
*
* Models
*
.model qn npn(is=5e-15 bf=150 rb=350 ptf=45 cjc=2pF tf=0.3nS)
.model qp pnp(is=5e-15 bf=150 rb=350 ptf=45 cjc=2pF tf=0.3nS)
*
.ends
