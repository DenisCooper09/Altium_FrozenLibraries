*
* Diode Model Produced by Altium Ltd
* Date:  3-May-2004
*
* Manufacturer: Renesas
* Component Name: HDSP-7507
*
* Parameters derived from information available in data sheet.
*
*                 common-anode
*                 |  cathode-PLUS
*                 |  |  cathode-MINUS
*                 |  |  |  common-anode
*                 |  |  |  |  cathode-DP
*                 |  |  |  |  |  cathode-c
*                 |  |  |  |  |  |  cathode-b
*                 |  |  |  |  |  |  |
.SUBCKT HDSP_7507 1  2  3  6  7  8  9

DPLUS1  1  2  dHDSP_7507
DMINUS1 1  3  dHDSP_7507
DB1     1  9  dHDSP_7507
DC1     1  8  dHDSP_7507
DDP1    1  7  dHDSP_7507

DPLUS2  6  2  dHDSP_7507
DMINUS2 6  3  dHDSP_7507
DB2     6  9  dHDSP_7507
DC2     6  8  dHDSP_7507
DDP2    6  7  dHDSP_7507

.MODEL dHDSP_7507 D
+ (
+     IS = 1.31238168E-27
+      N = 1.06196807
+     RS = 24.48189481
+     BV = 25
+    IBV = 100u
+ )

.ENDS HDSP_7507
