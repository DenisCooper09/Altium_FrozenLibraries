*
* Diode Model Produced by Altium Ltd
* Date:  10-Mar-2004
*
* Manufacturer: Agilent
* Component Name: HDSP-G01E
*
* Parameters derived from information available in data sheet.
*
*                 cathode-C-1
*                 |  cathode-E-1
*                 |  |  cathode-D-1
*                 |  |  |  common-anode-1
*                 |  |  |  |  common-anode-2
*                 |  |  |  |  |  cathode-D-2
*                 |  |  |  |  |  |  cathode-E-2
*                 |  |  |  |  |  |  |  cathode-C-2
*                 |  |  |  |  |  |  |  |  cathode-G-2
*                 |  |  |  |  |  |  |  |  |  cathode-A-2
*                 |  |  |  |  |  |  |  |  |  |  cathode-F-2
*                 |  |  |  |  |  |  |  |  |  |  |  cathode-B-2
*                 |  |  |  |  |  |  |  |  |  |  |  |  cathode-B-1
*                 |  |  |  |  |  |  |  |  |  |  |  |  |  cathode-F-1
*                 |  |  |  |  |  |  |  |  |  |  |  |  |  |  cathode-A-1
*                 |  |  |  |  |  |  |  |  |  |  |  |  |  |  |  cathode-G-1
*                 |  |  |  |  |  |  |  |  |  |  |  |  |  |  |  |
.SUBCKT HDSP_G01E 1  2  3  4  5  6  7  8  9  10 11 12 13 14 15 16

DA1 4 15 dHDSP_G01E
DB1 4 13 dHDSP_G01E
DC1 4  1 dHDSP_G01E
DD1 4  3 dHDSP_G01E
DE1 4  2 dHDSP_G01E
DF1 4 14 dHDSP_G01E
DG1 4 16 dHDSP_G01E

DA2 5 10 dHDSP_G01E
DB2 5 12 dHDSP_G01E
DC2 5  8 dHDSP_G01E
DD2 5  6 dHDSP_G01E
DE2 5  7 dHDSP_G01E
DF2 5 11 dHDSP_G01E
DG2 5  9 dHDSP_G01E

.MODEL dHDSP_G01E D
+ (
+     IS = 6.44208414E-14
+      N = 2.73863792
+     RS = 11.58628790
+     BV = 4.5
+    IBV = 100u
+ )

.ENDS HDSP_G01E
