*///////////////////////////////////////////////////////////////////////
* LT1028CS  Ultra Low Noise Precision High-Speed Operational Amplifier //
*///////////////////////////////////////////////////////////////////////
*
* connections:     non-inverting input
*                  |   inverting input
*                  |   |   positive power supply
*                  |   |   |   negative power supply
*                  |   |   |   |   output
*                  |   |   |   |   |
*                  |   |   |   |   |
.SUBCKT LT1028CS   3   2   7   4   6
X_LT1028CS 3 2 7 4 6 LT1028
.ENDS LT1028CS
*
*
.SUBCKT LT1028     3 2 7 4 6
RC1 7 80 7.0736E+01
RC2 7 90 7.0736E+01
Q1 80 2 10 QM1
Q2 90 3 11 QM2
*
C1 80 91 750E-12
RXC1 91 90 50
CXC1 91 90 400E-12
C2 1 98 30.000E-12
RXC2 98 8 1K
CXC2 98 8 10.000E-12
*
CIN 2 3 15E-12
RIN 2 3 2E4
DDM1 2 104 DM2
DDM3 104 3 DM2
DDM2 3 105 DM2
DDM4 105 2 DM2
RE1 10 12 -4.4157E+01
RE2 11 12 -4.4157E+01
IEE 12 4 4.5006E-04
RE 12 0 4.4439E+05
CE 12 0 1.5789E-12
GCM 0 8 12 0 7.0854E-09
GA 8 0 80 90 1.4137E-02
R2 8 0 1.0000E+05
GB 1 0 8 0 2.6731E+02
RO2 1 0 7.9000E+01
*
RS 1 6 1
ECL 18 0 1 6 2.7910E+01
GCL 0 8 20 0 1
RCL 20 0 1E3
D1 18 20 DM1
D2 20 18 DM1
*
D3A 131 70 DM3
D3B 13 131 DM3
GPL 0 8 70 7 1
VC 13 6 3.6394
RPLA 7 70 1E4
RPLB 7 131 1E5
D4A 60 141 DM3
D4B 141 14 DM3
GNL 0 8 60 4 1
VE 6 14 3.6394
RNLA 60 4 1E4
RNLB 141 4 1E5
*
IP 7 4 7.450E-03
DSUB 4 7 DM2
* MODELS
.MODEL QM1 NPN (IS=8.0000E-16 BF=5.7692E+03)
.MODEL QM2 NPN (IS=8.0062E-16 BF=1.0714E+04)
.MODEL DM1 D (IS=1.000E-19)
.MODEL DM2 D (IS=8.000E-16)
.MODEL DM3 D (IS=1.000E-20)
.ENDS LT1028
