*MCR100-8  SCR  A G K  MCE  7-17-95
*Ref: Motorola Thyristor Device Data, Q2/95
*MCE MCR100-8 600V  800mA  pkg:TO-226AA
.SUBCKT MCR100-8 1 2 3
*    TERMINALS:  A G K
*  600 Volt  .8 Amp  SCR  07-17-1995
QP  6 4 1  POUT OFF
QN  4 6 5  NOUT OFF
RF  6 4    120MEG
RR  1 4    80MEG
RGK 6 5    6.25K
RG  2 6    9.17
RK  3 5    81.3M
DF  6 4    ZF
DR  1 4    ZR
DGK 6 5    ZGK
.MODEL ZF   D (IS=.32F IBV=1U BV=600 RS=18MEG)
.MODEL ZR   D (IS=.32F IBV=1U BV=800)
.MODEL ZGK  D (IS=.32F IBV=1U BV=5)
.MODEL POUT PNP (IS=320F BF=1 CJE=67P)
.MODEL NOUT NPN (IS=320F BF=100 RC=.325
+ CJE=67P CJC=13.4P TF=56.6N TR=8.06U)
.ENDS MCR100-8
* Origin: Mcetriac.lib
