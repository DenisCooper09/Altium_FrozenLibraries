* BEGIN MODEL LMP7721
* Rev.A March-2008
*//////////////////////////////////////////////////////////////////////
* (C) National Semiconductor, Corporation.
* Models developed and under copyright by:
* National Semiconductor, Corporation.
*/////////////////////////////////////////////////////////////////////
* Legal Notice:
* The model may be copied, and distributed without any modifications;
* however, reselling or licensing the material is illegal.
* We reserve the right to make changes to the model without prior notice.
* PSPICE Models are provided "AS IS, WITH NO WARRANTY OF ANY KIND"
*////////////////////////////////////////////////////////////////////
* MODEL FEATURES INCLUDE OUTPUT SWING, OUTPUT CURRENT THRU THE SUPPLY RAILS,    * OUTPUT CURRENT LIMIT, OPEN LOOP GAIN AND PHASE WITH RL AND CL EFFECTS, SLEW   * RATE, COMMON MODE REJECTION WITH FREQ EFFECTS, POWER SUPPLY REJECTION WITH
* FREQ EFFECTS, INPUT VOLTAGE NOISE WITH 1/F, INPUT CURRENT NOISE, INPUT BIAS   * CURRENT, INPUT BIAS CURRENT TEMPERATURE EFFECTS, INPUT COMMON MODE RANGE,     * INPUT OFFSET VOLTAGE WITH TEMPERATURE EFFECTS, AND QUIESCENT CURRENT VS
* VOLTAGE AND TEMPERATURE.
*///////////////////////////////////////////////////////////////////////////////
* MODEL TEMP RANGE IS -40 TO +125 DEG C. NOTE THAT MODEL IS FUNCTIONAL OVER THIS * RANGE BUT NOT ALL PARAMETERS TRACK THOSE OF THE REAL PART
*///////////////////////////////////////////////////////////////////////////////
* PINOUT ORDER +IN -IN +V -V OUT
* PINOUT ORDER  3   4   5  2  1
.SUBCKT LMP7721 3 4 5 2 1
*
* USE V44 BELOW TO ADJUST OFFSET
* PRESENT VALUE OF 248.7 UV GIVES 26 UV NET
* NOTE THAT VOS CHANGES VIA CMRR,PSRR, AND TCVOS
* ADJUST UP OR DN FROM 248.7 UV
V44 26 11 248.7E-6
*
* USE R325 BELOW TO ADJUST BIAS CURRENT
* PRESENT VALUE OF 1E7 GIVES TYPICAL  IB
* USE              1E8 FOR WORST CASE IB
R325 0 100 1E7
*
* NOTE
* USE ANALYSIS OPTION GMIN OF 1E-13 TO 1E-15 AND
* RELTOL = 0.00001 TO 0.000001 FOR ACCURATE INPUT
* BIAS CURRENT
*
* MODEL FEATURES INCLUDE OUTPUT SWING, OUTPUT CURRENT THRU
* THE SUPPLY RAILS, OUTPUT CURRENT LIMIT, OPEN LOOP GAIN
* AND PHASE WITH RL AND CL EFFECTS, SLEW RATE, COMMON MODE
* REJECTION WITH FREQ EFFECTS, POWER SUPPLY REJECTION WITH
* FREQ EFFECTS, INPUT VOLTAGE NOISE WITH 1/F, INPUT CURRENT
* NOISE, INPUT BIAS CURRENT, INPUT BIAS CURRENT TEMPERATURE
* EFFECTS, INPUT COMMON MODE RANGE, INPUT OFFSET VOLTAGE
* WITH TEMPERATURE EFFECTS, AND QUIESCENT CURRENT VS
* VOLTAGE AND TEMPERATURE.
*
D17 6 0 DIN
D18 7 0 DIN
I14 0 6 0.1E-3
I15 0 7 0.1E-3
D19 8 0 DVN
D20 9 0 DVN
I16 0 8 0.1E-3
I17 0 9 0.1E-3
E15 10 4 8 9 0.7
G5 11 10 6 7 1.1E-14
E16 12 0 13 0 1
E17 14 0 15 0 1
E18 16 0 17 0 1
R56 12 18 1E6
R57 14 19 1E6
R58 16 20 1E6
R59 0 18 10
R60 0 19 10
R61 0 20 10
E19 21 22 20 0 1.4
R62 23 17 1E3
R63 17 24 1E3
C15 12 18 1E-12
C16 14 19 1E-12
C17 16 20 10E-12
E20 25 21 19 0 -6
E21 26 25 18 0 6
R64 0 27 1E12
G12 11 10 28 0 1.1E-6
R136 0 28 10E3
R137 0 28 10E3
R138 22 21 1E9
R139 21 25 1E9
R140 25 26 1E9
E54 24 0 11 0 1
E55 23 0 10 0 1
C23 11 10 0.05E-12
E57 22 3 29 0 8.45E-4
R146 22 3 1E9
R147 0 27 1E12
Q41 30 31 15 QLN
R148 31 32 1E3
R149 33 34 1E3
R150 35 13 5
R151 15 36 5
R153 37 38 200
R154 39 13 5
R155 15 40 5
D22 41 5 DD
D23 2 41 DD
E58 15 0 2 0 1
E59 13 0 5 0 1
R156 2 5 10E6
E67 42 15 13 15 0.5
D24 43 13 DD
D25 15 44 DD
R157 45 46 100
R158 47 48 100
G14 37 42 49 42 0.1E-3
R159 42 37 3.3E7
C24 38 50 5.25E-12
C25 41 0 0.5E-12
D26 48 30 DD
D27 51 46 DD
Q42 51 34 13 QLP
R160 41 52 1
R161 53 41 1
E61 54 42 55 56 1
R162 54 49 1E4
C26 49 42 0.3E-12
G15 57 42 37 42 -1E-3
G16 42 58 37 42 1E-3
G17 42 59 60 15 1E-3
G18 61 42 13 62 1E-3
D28 61 57 DD
D29 58 59 DD
R163 57 61 100E6
R164 59 58 100E6
R165 61 13 1E3
R166 15 59 1E3
R167 58 42 1E6
R168 59 42 1E6
R169 42 61 1E6
R170 42 57 1E6
G19 5 2 63 0 0.95E-3
R171 42 49 1E9
R172 45 13 1E9
R173 15 47 1E9
G20 62 60 27 0 0.1E-3
L2 41 1 0.4E-9
R175 41 1 400
R176 62 13 1E8
R177 15 60 1E8
R178 36 48 1E8
R179 35 46 1E8
R180 0 27 1E9
E99 13 33 13 35 1.9
E100 32 15 36 15 6.5
E124 50 0 41 0 1
R219 37 50 3.3E9
I30 0 64 1E-3
D46 64 0 DD
R278 0 64 10E6
V27 64 29 0.65
R279 0 29 10E6
Q52 52 46 35 QOP
Q53 53 48 36 QON
Q54 60 60 40 QON
Q55 62 62 39 QOP
E144 13 45 13 61 1
E145 47 15 59 15 1
I33 0 65 1E-3
D49 65 0 DD
R287 0 65 10E6
V130 65 66 1.2301
R288 0 66 10E6
E50 67 0 66 0 -1.75
R289 0 67 10E6
R290 68 67 10E6
M3 68 69 0 0 NEN L=2U W=1000U
G22 70 71 68 0 3E-6
V32 72 0 1
R791 72 69 1E6
M4 69 27 0 0 NEN L=2U W=100U
E51 37 44 42 15 0.7
E52 43 37 13 42 0.7
G23 5 0 52 41 1
G24 2 0 41 53 -1
V35 13 73 1
M45 74 75 76 76 NEN L=3U W=3000U
R293 76 77 1E4
R294 74 13 1E6
V36 13 76 1
C110 13 73 1E-12
E53 27 0 78 76 1
V37 74 78 1.111E-6
R295 76 78 1E12
R296 73 13 1E6
C111 77 76 3E-15
C112 13 74 3E-15
M20 79 80 76 76 NEN L=3U W=300U
M21 75 79 76 76 NEN L=3U W=300U
R297 79 13 1E4
R298 75 13 1E4
C113 13 79 55E-12
C114 13 75 150E-12
E154 81 37 27 0 30
E155 82 42 27 0 -30
V138 83 82 15
V139 84 81 -15
R300 81 0 1E12
R301 82 0 1E12
M12 42 84 37 85 PSW L=1.5U W=150U
M13 37 83 42 86 NSW L=1.5U W=150U
R302 85 0 1E12
R303 86 0 1E12
M14 77 73 13 13 PEN L=6U W=60U
E156 87 76 77 76 -1
R304 76 87 10E6
R305 76 87 10E6
V40 80 87 1
R306 76 80 10E6
M55 88 89 2 2 NEN L=2U W=1000U
R809 88 5 100E3
E37 89 2 27 0 3
M56 63 90 0 0 NEN L=2U W=10M
R811 63 67 850E3
E60 91 0 27 0 -1
R312 0 91 10E6
R313 0 91 10E6
V43 90 91 1
R814 0 90 10E6
G25 5 2 27 0 -0.33E-3
G26 5 2 92 0 0.7E-4
E161 93 0 5 2 1
M57 92 90 0 0 NEN L=2U W=10M
R815 92 93 75E3
R317 4 10 1E9
R319 94 56 2E3
R320 94 55 2E3
C47 56 55 1.2E-12
M58 56 95 96 96 PIN L=3U W=650U
M59 55 97 98 98 PIN L=3U W=650U
Q58 99 70 71 QPI
R321 11 95 40
R322 10 97 40
R323 96 99 1
R324 98 99 1
V145 13 71 0.2
V46 94 15 0
D50 100 101 DL
V47 101 0 3
G51 10 0 100 0 1.6E-11
I61 10 0 1E-15
G52 11 0 100 0 1.6E-11
I62 11 0 1E-15
J1 102 95 102 JC
J2 95 103 95 JC
J3 102 97 102 JC
J4 97 103 97 JC
V48 13 102 0.48
V49 103 15 0.15
G53 104 3 104 3 2.5E-13
G54 104 4 104 4 2.5E-13
V146 104 15 1
.MODEL DL D IS=0.95E-11 N=1.9 XTI=1.5
.MODEL JC NJF IS=1E-18
.MODEL QPI PNP
.MODEL QON NPN RC=5
.MODEL QOP PNP RC=5
.MODEL DD D
.MODEL DVN D KF=2.5E-15
.MODEL DIN D KF=8E-17
.MODEL QLN NPN
.MODEL QLP PNP
.MODEL PIN PMOS KP=200U VTO=-0.7
.MODEL NIQS NMOS KP=200U VTO=0.7 IS=1E-18
.MODEL NEN NMOS KP=200U VTO=0.5 IS=1E-18
.MODEL PEN PMOS KP=200U VTO=-0.7 IS=1E-18
.MODEL PSW PMOS KP=200U VTO=-7.5 IS=1E-18
.MODEL NSW NMOS KP=200U VTO=7.5 IS=1E-18
.ENDS
* END MODEL LMP7721
