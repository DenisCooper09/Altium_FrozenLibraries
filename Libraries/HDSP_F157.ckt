*
* Diode Model Produced by Altium Ltd
* Date:  10-Mar-2004
*
* Manufacturer: Agilent
* Component Name: HDSP-F157
*
* Parameters derived from information available in data sheet.
*
*                 common-anode
*                 |  cathode-PLUS
*                 |  |  cathode-MINUS
*                 |  |  |  common-anode
*                 |  |  |  |  cathode-DP
*                 |  |  |  |  |  cathode-c
*                 |  |  |  |  |  |  cathode-b
*                 |  |  |  |  |  |  |
.SUBCKT HDSP_F157 1  2  3  6  7  8  9

DPLUS1  1 2 dHDSP_F157
DMINUS1 1 3 dHDSP_F157
DB1     1 9 dHDSP_F157
DC1     1 8 dHDSP_F157
DDP1    1 7 dHDSP_F157

DPLUS2  6 2 dHDSP_F157
DMINUS2 6 3 dHDSP_F157
DB2     6 9 dHDSP_F157
DC2     6 8 dHDSP_F157
DDP2    6 7 dHDSP_F157

.MODEL dHDSP_F157 D
+ (
+    IS  = 1.31055154E-15
+     N  = 2.20660855
+    RS  = 1.60736539
+    BV  = 14.25
+   IBV  = 100u
+ )

.ENDS HDSP_F157
