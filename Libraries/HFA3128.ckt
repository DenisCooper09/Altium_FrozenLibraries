.SUBCKT HFA3128 1 2 3
X1 1 2 3 PUHF
.ENDS HFA3128
*HFA3046/3096/3127/3128 PSpice MODEL
*REV: 12-2-93 Added updated PNP model
*
*      -----  BJT MODELS  -----
*
***** UHFP - LE=3 WE=50  *****
*
.SUBCKT PUHF 1 2 3
Q1 1 2 3 PUHFARRY
.model PUHFARRY PNP
+     ( IS= 1.027E-16    XTI= 3.000E+00     EG= 1.110E+00    VAF= 3.000E+01
+      VAR= 4.500E+00     BF= 5.228E+01    ISE= 9.398E-20     NE= 1.400E+00
+      IKF= 5.412E-02    XTB= 0.000E+00     BR= 7.000E+00    ISC= 1.027E-14
+       NC= 1.800E+00    IKR= 5.412E-02     RC= 3.420E+01    CJC= 4.951E-13
+      MJC= 3.000E-01    VJC= 1.230E+00     FC= 5.000E-01    CJE= 2.927E-13
+      MJE= 5.700E-01    VJE= 8.800E-01     TR= 4.000E-09     TF= 20.05E-12
+      ITF= 2.001E-02    XTF= 1.534E+00    VTF= 1.800E+00    PTF= 0.000E+00
+     XCJC= 9.000E-01    CJS= 1.150E-13    VJS= 7.500E-01    MJS= 0.000E+00
+       RE= 1.848E+00     RB= 3.271E+01    RBM= 9.902E-01     KF= 0.000E+00
+       AF= 1.000E+00  )
.ENDS PUHF
