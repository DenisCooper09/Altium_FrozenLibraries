*ZETEX  ZTX705 Darlington Spice Subcircuit   Last revision  9/8/90
*
.SUBCKT ZTX705 1 2 3
*              C B E
Q1 1 2 4 SUB704
Q2 1 4 3 SUB704 4
*
.MODEL SUB704 PNP IS =3.35584E-14 BF =85 VAF=212 NF =1.002 IKF=.817
+ISE=3.6E-13 NE =4.1 BR =24 VAR=6 NR =.999 IKR=.114 ISC=1.406E-13 NC =1.13
+RB =1.1 RE =.4 RC =.0339 CJE=100E-12 CJC=37E-12 VJC=1.045 MJC=.595
.ENDS ZTX705
*
*                          (C)  1991 ZETEX PLC
*
*   The copyright in this model  and  the design embodied belong to
*   Zetex PLC ("Zetex"). It is supplied free of charge by Zetex for
*   the purpose  of research  and design  and may be used or copied
*   intact (including this notice) for that purpose only. All other
*   rights  are  reserved.  The model  is believed  accurate but no
*   condition or warranty as to its  merchantability or fitness for
*   purpose  is  given  and  no liability  in respect of any use is
*   accepted by Zetex PLC, its distributors or agent.
*
*
*   Zetex PLC, Fields New Road, Chadderton, Oldham  OL9 8NP

