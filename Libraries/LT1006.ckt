*//////////////////////////////////////////////////////////
* LT1006 Precision, Single Supply Operational Amplifier //
*//////////////////////////////////////////////////////////
*
* connections:     non-inverting input
*                  |   inverting input
*                  |   |   positive power supply
*                  |   |   |   negative power supply
*                  |   |   |   |   output
*                  |   |   |   |   |
*                  |   |   |   |   |
.SUBCKT LT1006     1   2   3   4   5
*
C1 11 12 8.661E-12
C2 6 7 30.00E-12
DC 8 53 DX
DE 54 8 DX
DLP 90 91 DX
DLN 92 90 DX
DP 4 3 DX
EGND 99 0 POLY(2) (3,0) (4,0) 0 .5 .5
FB 7 99 POLY(5) VB VC VE VLP VLN 0 2.475E9 -2E9 2E9 2E9 -2E9
GA 6 0 11 12 113.1E-6
GCM 0 6 10 99 225.7E-12
IEE 3 10 DC 12.03E-6
HLIM 90 0 VLIM 1K
Q1 11 102 13 QM1
Q2 12 101 14 QM2
RB1 2 102 400
RB2 1 101 400
DCM1 105 102 DX
DCM2 105 101 DX
VCMC 105 4 DC 0.4
R2 6 9 100.0E3
RC1 4 11 8.841E3
RC2 4 12 8.841E3
RE1 13 10 4.519E3
RE2 14 10 4.519E3
REE 10 99 16.63E6
RO1 8 5 80
RO2 7 99 25
IP 3 4 328E-6
VB 9 0 DC 0
VC 3 53 DC 1.610
VE 54 4 DC .61
VLIM 7 8 DC 0
VLP 91 0 DC 25
VLN 0 92 DC 25
.MODEL DX D(IS=800.0E-18)
.MODEL QM1 PNP (IS=8.000E-16 BF=5.955E+02)
.MODEL QM2 PNP (IS=8.009E-16 BF=6.045E+02)
.ENDS LT1006
