*/////////////////////////////////////////////////////////////////////////
* LT1219  Precision Rail-to-Rail Input and Output Operational Amplifier //
*/////////////////////////////////////////////////////////////////////////
*
* connections:     non-inverting input
*                  |   inverting input
*                  |   |   positive power supply
*                  |   |   |   negative power supply
*                  |   |   |   |   output
*                  |   |   |   |   |   SHUTDOWN
*                  |   |   |   |   |   |
.SUBCKT LT1219     1   2   3   4   5   8
GRP1 1 111 1 111 1.0000e+000
GRP2 119 112 119 112 1.0000e+000
DIP1 114 111 DX
DIP2 114 112 DX
VCM 114 4 DC 4.9000e-001
GSW1 2 119 POLY(2) 803 99 2 119 0 0 1e-9 0 0 0 0 0 0 0 0 0 0 0 0 0 0 0 0
+  0 0 0 0 0 0 0 0 0 0 0 0 0 0 0 0 0 0 0 0 0
+  0 0 0 0 0 0 2.56e-6
RGSW1 2 119 1.0000e+009
CIN 111 112 1.2000e-011
GRIN 111 112 111 112 1.1244e-007
Q1 11 112 13 Q1
Q2 12 113 14 Q2
RC1 303 11 2.4091e+003
RC2 303 12 2.4091e+003
RE1 10 13 3.7722e+001
RE2 10 14 3.7722e+001
C1 11 12 3.3032e-011
IEE 10 304 DC 8.3021e-004
GSHDN 10 304 806 99 1.6772e-004
D1 304 10 DX
VCMEP 303 3 DC 1.4
VCMEN 4 304 DC 0.6
GA 60 99 11 12 4.1509e-004
FRI1 99 1 VRI1 1
VRI1 101 0 DC 0
RRI1 101 0 7.1260e+006
FRI2 99 2 VRI2 1
VRI2 201 0 DC 0
RRI2 201 0 7.1260e+006
GR 99 60 605 606 1.5930e+001
IR1 0 605 DC 1
IR2 0 606 DC 1
DR1 605 0 DR
DR2 606 0 DR
GCM1 99 20 POLY(2) 111 99 112 99 0 5.0000e-004 5.0000e-004
RCM1 21 99 1.000000e+003
RCM2 20 99 1.0000e+006
LCM 20 21 1.5915e+000
ECM 113 111 20 99 3.1623e-006
RP1 601 99 1.4286e+003
CP1 60 601 1.3926e-009
RP11 60 99 1.0000e+004
GP1 99 61 60 99 1.0000e-004
RP2 611 99 1.0870e+004
LP2 61 611 2.1624e-002
RP22 61 99 1.2500e+005
GP2 99 6 61 99 1.0000e-004
R2 6 99 1.0000e+003
C2 6 7 9.9472e-009
GB 7 99 6 99 3.9016e+003
R01 7 99 2.5631e+001
R02 7 50 1.0000e-001
R03 50 51 3.4269e+001
GSW2 51 5 POLY(2) 803 99 51 5 0 0 1e-9 0 0 0 0 0 0 0 0 0 0 0 0 0 0 0 0
+  0 0 0 0 0 0 0 0 0 0 0 0 0 0 0 0 0 0 0 0 0
+  0 0 0 0 0 0 2.56e-6
R04 5 99 1.0000e+012
VC 53 50 DC 1.0738e+000
VE 54 50 DC -1.0748e+000
DC1 53 55 DX
DC2 55 56 DX
DE1 57 54 DX
DE2 58 57 DX
GVC1 3 56 3 56 1.0E-4
GVE1 4 58 4 58 1.0E-4
GVC2 3 55 3 55 1.0E-5
GVE2 4 57 4 57 1.0E-5
GVLP 99 60 56 3 1.0000e+000
GVLN 99 60 58 4 1.0000e+000
ECLP 91 0 7 50 1.0000e+003
ECLN 92 0 7 50 1.0000e+003
DCLP 91 90 DX
DCLN 90 92 DX
VLIM 90 0 DC 0
FB 7 99 VLIM 6.4086e+001
EGND 99 0 POLY(2) 3 0 4 0 0 0.5 0.5
DSUB 4 3 DX
GIP 3 4 POLY(1) 99 803 1.0072e-005 -9.3043e-005
GV 31 0 7 50 1.0000e+001
DP1 3 31 DX
DP2 33 4 DX
RGV 32 33 10.0
EGV 31 32 POLY(1) 3 4 -0.85 1.0
RDIS1 8 3 1.0000e+012
DDIS1 801 8 DX
RDIS2 801 802 1.1809e+006
VDIS1 800 802 DC 0
EDIS 3 800 3 99 0.35
FDIS 99 803 POLY(1) VDIS1 -30E-3 1.6667e+004
RDIS3 803 99 1.0000e+003
DDIS2 803 804 DON
VDIS2 804 99 DC -8.0100e-001
DDIS3 805 803 DOFF
VDIS3 805 99 DC -4.1950e+000
CDIS1 803 99 5.0000e-011
EDIS2 806 99 POLY(1) 803 99 -5.0 -1.0
RDIS4 806 99 1.0000e+006

.MODEL DX D (IS=8.0000e-016 RS=0 XTI=0)
.MODEL Q1 NPN  (IS=9.9950e-016 BF=20896.9 XTB=-1.1070e+001
+ XTI=2.99472e+000 KF=1.6305e-016)
.MODEL Q2 NPN  (IS=1.0005e-015 BF=23778.7 XTB=-9.5221e+000
+ XTI=3.00528e+000 KF=1.6305e-016)
.MODEL DR D (IS=8.0000e-016 KF=3.2111e-018 RS=0 XTI=0)
.MODEL DON D (IS=8.0000e-016 TT=0.0000e+000 CJO=0.3E-12 RS=0 XTI=0)
.MODEL DOFF  D (IS=8.0000e-016 TT=3.6000e-005 CJO=0.3E-12 RS=0 XTI=0)
*jg, 29/6/2000: corrected model syntax.

.ENDS LT1219
*
