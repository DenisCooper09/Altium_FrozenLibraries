*
* Diode Model Produced by Altium Ltd
* Date:  3-May-2004
*
* Manufacturer: Renesas
* Component Name: HDSP-7808
*
* Parameters derived from information available in data sheet.
*
*                 common-cathode
*                 |  anode-PLUS
*                 |  |  anode-MINUS
*                 |  |  |  common-cathode
*                 |  |  |  |  anode-DP
*                 |  |  |  |  |  anode-c
*                 |  |  |  |  |  |  anode-b
*                 |  |  |  |  |  |  |
.SUBCKT HDSP_7808 1  2  3  6  7  8  9

DPLUS1  2  1  dHDSP_7808
DMINUS1 3  1  dHDSP_7808
DB1     9  1  dHDSP_7808
DC1     8  1  dHDSP_7808
DDP1    7  1  dHDSP_7808

DPLUS2  2  6  dHDSP_7808
DMINUS2 3  6  dHDSP_7808
DB2     9  6  dHDSP_7808
DC2     8  6  dHDSP_7808
DDP2    7  6  dHDSP_7808

.MODEL dHDSP_7808 D
+ (
+     IS = 1.61114016E-27
+      N = 1.30291189
+     RS = 12.83456794
+     BV = 50
+    IBV = 100u
+ )

.ENDS HDSP_7808
