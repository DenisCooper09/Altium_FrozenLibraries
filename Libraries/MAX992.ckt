*   ////////////// MAX992 MACROMODEL //////////////////
* * MAX992         Dual, Open-Drain
*
*   ====>      REFER TO MAX987 DATA SHEET       <====
*
*
*Connections :   non-inverting input
*                | inverting input
*                | | positive power supply
*                | | | negative power supply
*                | | | | open drain output
*                | | | | |
.SUBCKT MAX992   1 2 3 4 5
*
  F1    3  9 v1 1
  Iee   7  4 dc 100.0E-6
  vi1   1 21 dc .75
  vi2   2 22 dc .75
  ****
  q1    9 22  7 qin
  q2    8 21  7 qin
  q3    9  8  3 qmo
  q4    8  8  3 qmi
.model qin NPN(Is=800.0E-18 Bf=50.00E6)
.model qmi PNP(Is=800.0E-18 Bf=1002)
.model qmo PNP(Is=800.0E-18 Bf=1000 Cjc=1E-15 Tr=174.9E-9)
  E1   10  4  3  9  1
  v1   10 11 dc 0
  q5    5 11  4 qoc
  ***
.model qoc NPN(Is=800.0E-18 Bf=20.29E3 Cjc=1E-15 Tf=187.0E-12 Tr=117.7E-9)
  dp    4  3 dx
  .model dx  D(Is=800.0E-18)
*
.ENDS
