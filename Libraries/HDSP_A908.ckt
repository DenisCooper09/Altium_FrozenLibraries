*
* Diode Model Produced by Altium Ltd
* Date:  7-Apr-2004
*
* Manufacturer: Agilent
* Component Name: HDSP-A908
*
* Parameters derived from information available in data sheet.
*
*                 common-cathode
*                 |  anode-PLUS
*                 |  |  anode-MINUS
*                 |  |  |  common-cathode
*                 |  |  |  |  anode-DP
*                 |  |  |  |  |  anode-c
*                 |  |  |  |  |  |  anode-b
*                 |  |  |  |  |  |  |
.SUBCKT HDSP_A908 1  2  3  6  7  8  9

DPLUS1  2  1 dHDSP_A908
DMINUS1 3  1 dHDSP_A908
DB1     9  1 dHDSP_A908
DC1     8  1 dHDSP_A908
DDP1    7  1 dHDSP_A908

DPLUS2  2  6 dHDSP_A908
DMINUS2 3  6 dHDSP_A908
DB2     9  6 dHDSP_A908
DC2     8  6 dHDSP_A908
DDP2    7  6 dHDSP_A908

.MODEL dHDSP_A908 D
+ (
+     IS = 1.37135099E-36
+      N = 0.94257009
+     RS = 17.99091536
+     BV = 30
+    IBV = 100u
+ )

.ENDS HDSP_A908
