*
* Diode Model Produced by Altium Ltd
* Date:  7-Apr-2004
*
* Manufacturer: Agilent
* Component Name: HDSP-7517
*
* Parameters derived from information available in data sheet.
*
*                 common-anode
*                 |  cathode-PLUS
*                 |  |  cathode-MINUS
*                 |  |  |  common-anode
*                 |  |  |  |  cathode-DP
*                 |  |  |  |  |  cathode-c
*                 |  |  |  |  |  |  cathode-b
*                 |  |  |  |  |  |  |
.SUBCKT HDSP_7517 1  2  3  6  7  8  9

DPLUS1  1  2 dHDSP_7517
DMINUS1 1  3 dHDSP_7517
DB1     1  9 dHDSP_7517
DC1     1  8 dHDSP_7517
DDP1    1  7 dHDSP_7517

DPLUS2  6  2 dHDSP_7517
DMINUS2 6  3 dHDSP_7517
DB2     6  9 dHDSP_7517
DC2     6  8 dHDSP_7517
DDP2    6  7 dHDSP_7517

.MODEL dHDSP_7517 D
+ (
+     IS = 7.07436607E-24
+      N = 1.24380258
+     RS = 22.12166762
+     BV = 30
+    IBV = 100u
+ )

.ENDS HDSP_7517
