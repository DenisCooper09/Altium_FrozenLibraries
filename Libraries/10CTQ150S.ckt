*10CTQ150S MCE 3/27/98
*Ref: IR Power Semiconductors Product Digest '94
*MCE 150V 10A 3us pkg:D2PAK 1,2,3
.SUBCKT 10CTQ150S 1 2 3
D1 1 2 DA
D2 3 2 DA
.MODEL DA D (IS=14.2N RS=4.2M N=1.7 BV=150 IBV=7M
+ CJO=412P VJ=0.75 M=0.333 TT=4.32U EG=.69 XTI=2)
.ENDS 10CTQ150S
