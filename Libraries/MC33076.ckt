*MC33076 OPERATIONAL AMPLIFIER "MACROMODEL" SUBCIRCUIT
*
* Connections:
*                Non-Inverting Input
*                | Inverting Input
*                | | Positive Power Supply
*                | | | Negative Power Supply
*                | | | | Output
*                | | | | |
.SUBCKT MC33076  1 2 3 4 5
  C1   11 12 30.302E-12
  C2    6  7 18.00E-12
  DC  500 53 DX
  DE   54  500 DX
  DLP  90 91 DX
  DLN  92 90 DX
  DP    4  3 DX
*EGND 99  0 POLY(2) (3,0) (4,0) 0 .5 .5
  BEGND 99  0 V=.5*v(3,0)+.5*v(4,0)
*FB    7 99 POLY(5) VB VC VE VLP VLN 0 20.21E6 -20E6 20E6 20E6 -20E6
  BFB    7 99 I=20.21E6*I(VB)-20E6*I(VC)+20E6*I(VE)+20E6*I(VLP)-20E6*I(VLN)
  GA    6  0 11 12 395.8E-6
  GCM   0  6 10 99 627.4E-12
  IEE  10  4 DC 47.16E-6
  HLIM 90  0 VLIM 1K
  Q1   11  2 13 QX
  Q2   12  1 14 QX
  R2    6  9 100.0E3
  RC1   3 11 2.526E3
  RC2   3 12 2.526E3
  RE1  13 10 1.410E3
  RE2  14 10 1.410E3
  REE  10 99 4.241E6
  RO1   8  500 25
  RO2   7 99 25
  RP    3  4 13.93E3
  VB    9  0 DC 0
  VC    3 53 DC .92
  VE   54  4 DC .86
  VLIM  7  8 DC 0
  VLP  91  0 DC 250
  VLN   0 92 DC 250
  EVCS1  800  500  8  500 1.0
  EVCS2  500  820  810  500 1.0
  RVS1   800  810  75
  CVS    810  500  500P
  RVS2   820   5   50
  DESD1  1  3 DX
  DESD2  2  3 DX
.MODEL DX D(IS=800.0E-18)
.MODEL QX NPN(IS=800.0E-18 BF=130)
.ENDS MC33076
