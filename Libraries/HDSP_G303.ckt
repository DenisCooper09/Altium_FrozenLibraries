*
* Diode Model Produced by Altium Ltd
* Date:  10-Mar-2004
*
* Manufacturer: Agilent
* Component Name: HDSP-G303
*
* Parameters derived from information available in data sheet.
*
*                 e-anode-1
*                 |  d-anode-1
*                 |  |  c-anode-1
*                 |  |  |  dp-anode-1
*                 |  |  |  |  e-anode-2
*                 |  |  |  |  |  d-anode-2
*                 |  |  |  |  |  |  g-anode-2
*                 |  |  |  |  |  |  |  c-anode-2
*                 |  |  |  |  |  |  |  |  dp-anode-2
*                 |  |  |  |  |  |  |  |  |  b-anode-2
*                 |  |  |  |  |  |  |  |  |  |  a-anode-2
*                 |  |  |  |  |  |  |  |  |  |  |  f-anode-2
*                 |  |  |  |  |  |  |  |  |  |  |  |  common-cathode-2
*                 |  |  |  |  |  |  |  |  |  |  |  |  |  common-cathode-1
*                 |  |  |  |  |  |  |  |  |  |  |  |  |  |  b-anode-1
*                 |  |  |  |  |  |  |  |  |  |  |  |  |  |  |  a-anode-1
*                 |  |  |  |  |  |  |  |  |  |  |  |  |  |  |  |  g-anode-1
*                 |  |  |  |  |  |  |  |  |  |  |  |  |  |  |  |  |  f-anode-1
*                 |  |  |  |  |  |  |  |  |  |  |  |  |  |  |  |  |  |
.SUBCKT HDSP_G303 1  2  3  4  5  6  7  8  9  10 11 12 13 14 15 16 17 18

DA1  16 14 dHDSP_G303
DB1  15 14 dHDSP_G303
DC1   3 14 dHDSP_G303
DD1   2 14 dHDSP_G303
DE1   1 14 dHDSP_G303
DF1  18 14 dHDSP_G303
DG1  17 14 dHDSP_G303
DDP1  4 14 dHDSP_G303

DA2  11 13 dHDSP_G303
DB2  10 13 dHDSP_G303
DC2   8 13 dHDSP_G303
DD2   6 13 dHDSP_G303
DE2   5 13 dHDSP_G303
DF2  12 13 dHDSP_G303
DG2   7 13 dHDSP_G303
DDP2  9 13 dHDSP_G303

.MODEL dHDSP_G303 D
+ (
+     IS = 6.04055825E-18
+      N = 1.90788337
+     RS = 23.52447762
+     BV = 40
+    IBV = 100u
+ )

.ENDS HDSP_G303
