*
* Diode Model Produced by Altium Ltd
* Date:  10-Mar-2004
*
* Manufacturer: Agilent
* Component Name: HDSP-F307
*
* Parameters derived from information available in data sheet.
*
*                 common-anode
*                 |  cathode-PLUS
*                 |  |  cathode-MINUS
*                 |  |  |  common-anode
*                 |  |  |  |  cathode-DP
*                 |  |  |  |  |  cathode-c
*                 |  |  |  |  |  |  cathode-b
*                 |  |  |  |  |  |  |
.SUBCKT HDSP_F307 1  2  3  6  7  8  9

DPLUS1  1 2 dHDSP_F307
DMINUS1 1 3 dHDSP_F307
DB1     1 9 dHDSP_F307
DC1     1 8 dHDSP_F307
DDP1    1 7 dHDSP_F307

DPLUS2  6 2 dHDSP_F307
DMINUS2 6 3 dHDSP_F307
DB2     6 9 dHDSP_F307
DC2     6 8 dHDSP_F307
DDP2    6 7 dHDSP_F307

.MODEL dHDSP_F307 D
+ (
+     IS = 6.04055825E-18
+      N = 1.90788337
+     RS = 23.52447762
+     BV = 40
+    IBV = 100u
+ )

.ENDS HDSP_F307
