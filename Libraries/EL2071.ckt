*EL2071 Macromodel
* Revision A, March 1992
* Enhancements include PSRR, CMRR, and Slew Rate Limiting
* Connections:          +input
*                       |   -input
*                       |   |   +Vsupply
*                       |   |   |   -Vsupply
*                       |   |   |   |   output
*                       |   |   |   |   |
.subckt EL2071          3   2   7   4   6
*
* Input Stage
*
e1  10 0 3 0 1.0
vis 10  9 0V
h2   9 12 vxx 1.0
r1  2  11  2
l1 11  12  1nH
iinp 3  0 10uA
iinm 2  0 10uA
*
* Slew Rate Limiting
*
*h1 13 0 vis 1K
h1 13 0 vis 600
r2 13 14 100
d1 14  0  dclamp
d2  0 14  dclamp
*
* High Frequency Pole
*
*e2 30  0 14 0 0.00166666666
e2 30 0 14 0 0.001
l3 30 17 0.1uH
c5 17  0 0.1pF
r5 17  0 500
*
* Transimpedance Stage
*
g1  0 18 17 0 1.0
rol 18 0 1Meg
cdp 18 0 0.88pF
*
* Output Stage
*
q1 4 18 19 qp
q2 7 18 20 qn
q3 7 19 21 qn
q4 4 20 22 qp
r7 21 6  2
r8 22 6  2
ios1 7 19 2.5mA
ios2 20 4 2.5mA
*
* Supply Current
*
ips 7 4 9mA
*
* Error Terms
*
ivos 0 23 3mA
vxx 23  0 0V
e4  24 0 3 0 1.0
e5  25 0 7 0 1.0
e6  26 0 4 0 1.0
r9  24 23 316
r10 25 23 562
r11 26 23 562
*
* Models
*
.model qn npn(is=5e-15 bf=500 tf=0.05nS)
.model qp pnp(is=5e-15 bf=500 tf=0.05nS)
.model dclamp d(is=1e-30 ibv=1pA bv=3.5 n=4)
.ends
