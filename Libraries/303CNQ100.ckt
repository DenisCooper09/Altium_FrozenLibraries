*303CNQ100 MCE 3/30/98
*Ref: IR Power Semiconductors Product Digest '94
*MCE 100V 300A 3us pkg:TO-244 1,2,3
.SUBCKT 303CNQ100 1 2 3
D1 1 2 DA
D2 3 2 DA
.MODEL DA D (IS=426N RS=140U N=1.7 BV=100 IBV=0.105
+ CJO=12.3N VJ=0.75 M=0.333 TT=4.32U EG=.69 XTI=2)
.ENDS 303CNQ100
