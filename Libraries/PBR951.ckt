* PBR951.PRM  SPICE MODEL OF BJT TYPE PBR951
* PHILIPS SEMICONDUCTORS
* Date : April 1997
* PACKAGE : SOT23     DIE MODEL : XB520
* 1: PACKED COLLECTOR; 2: PACKED BASE; 3: PACKED EMITTER;
.SUBCKT PBR951 1 2 3
Q1 6 5 7 7 XB520
* SOT23 parasitic model including bondpads
               Lb  4 5 .4n
               Le  7 8 .83n
               L1  2 4 .35n
               L2  1 6 .17n
               L3  3 8 .35n
              Ccb  4 6  80f
              Cbe  4 8   7f
              Cce  6 8  80f
              Cbpb 5 6  73f
              Cbpe 7 6 131f
*
* PHILIPS SEMICONDUCTORS     Version:   1.0
* Filename:    XB520.PRM     Date: Mar 1 1996
* extracted batch 49917-5
.MODEL  XB520   NPN
+(
+              IS = 9.631E-16
+              BF = 102.3
+              NF = 1.002
+             VAF = 64.75
+             IKF = 0.8411
+             ISE = 3.577E-12
+              NE = 2.138
+              BR = 90.16
+              NR = 1
+             VAR = 3.198
+             IKR = 0.02577
+             ISC = 1.566E-16
+              NC = 1.047
+              RB = 6.071
+             IRB = 0
+             RBM = 2.478
+              RE = 0.1638
+              RC = 1.315
+             CJE = 1.161E-12
+             VJE = 0.6
+             MJE = 0.3937
+             CJC = 4.099E-13
+             VJC = 0.2871
+             MJC = 0.1105
+             CJS = 0
+             VJS = 0.7
+             MJS = 0
+            XCJC = 0.1042
+              TR = 0
+              TF = 3.073E-12
+             XTF = 10.25
+             VTF = 4.599
+             ITF = 0.05349
+             PTF = 0
+              FC = 0.8878
+              EG = 1.11
+             XTI = 3
+              AF = 1
+              KF = 4.00E-16
+)
* Parameters with default value: XTB, EG, XTI, CJS, VJE, VJS and MJS.
* BONDPAD CAPACITORS Cbpb=73E-15 Cbpe=131E-15 not included in this model!
.ENDS
