*
* Diode Model Produced by Altium Ltd
* Date:  7-Apr-2004
*
* Manufacturer: Agilent
* Component Name: HDSP-H107
*
* Parameters derived from information available in data sheet.
*
*                 cathode-c
*                 |  anode-c,d
*                 |  |  cathode-b
*                 |  |  |  anode-a,b DP
*                 |  |  |  |  cathode-DP
*                 |  |  |  |  |  cathode-a
*                 |  |  |  |  |  |  anode-a,b DP
*                 |  |  |  |  |  |  |  anode-c,d
*                 |  |  |  |  |  |  |  |  cathode-d
*                 |  |  |  |  |  |  |  |  |
.SUBCKT HDSP_H107 1  2  3  4  5  6  7  8  9

DA1  4  6 dHDSP_H107
DB1  4  3 dHDSP_H107
DDP1 4  5 dHDSP_H107

DA2  7  6 dHDSP_H107
DB2  7  3 dHDSP_H107
DDP2 7  5 dHDSP_H107

DC1  2  1 dHDSP_H107
DD1  2  9 dHDSP_H107

DC2  8  1 dHDSP_H107
DD2  8  9 dHDSP_H107

.MODEL dHDSP_H107 D
+ (
+    IS  = 2.08276754E-16
+     N  = 2.17799178
+    RS  = 0.50892350
+    BV  = 14.25
+   IBV  = 100u
+ )

.ENDS HDSP_H107
