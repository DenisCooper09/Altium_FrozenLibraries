*

*

*  ------------------------------------------------------------------------

* |  NOTICE: THE INFORMATION PROVIDED HEREIN IS BELIEVED TO BE RELIABLE;   |

* |  HOWEVER; BURR-BROWN ASSUMES NO RESPONSIBILITY FOR INACCURACIES OR     |

* |  OMISSIONS.  BURR-BROWN ASSUMES NO RESPONSIBILITY FOR THE USE OF THIS  |

* |  INFORMATION, AND ALL USE OF SUCH INFORMATION SHALL BE ENTIRELY AT     |

* |  THE USER'S OWN RISK.  NO PATENT RIGHTS OR LICENSES TO ANY OF THE      |

* |  CIRCUITS DESCRIBED HEREIN ARE IMPLIED OR GRANTED TO ANY THIRD PARTY.  |

* |  BURR-BROWN DOES NOT AUTHORIZE OR WARRANT ANY BURR-BROWN PRODUCT FOR   |

* |  USE IN LIFE-SUPPORT DEVICES AND/OR SYSTEMS.                           |

*  ------------------------------------------------------------------------

*

*

*

* INA128 = A1_128 + A2_128 + A3_128 OP AMPS + PRECISION RESISTOR NETWORK

* CREATED ON 11/20/96 AT 15:01

*

*  Note:  A1_128, A2_128 and A3_128 op amps modeled here for the INA128

*         ARE NOT related to any standard BB op amps such as the OPA128.

*

* REV.B  18 JUNE 97 NPA: MOVED LEGAL DISCLAIMER TO BEGINNING OF FILE

*

*

***** INA128 SUB-CIRCUIT

* CONNECTIONS:          NON-INVERTING INPUT

*                       |   INVERTING INPUT

*                       |   |   POSITIVE POWER SUPPLY

*                       |   |   |   NEGATIVE POWER SUPPLY

*                       |   |   |   |   OUTPUT

*                       |   |   |   |   |   REFERENCE

*                       |   |   |   |   |   |   GAIN SENSE 1

*                       |   |   |   |   |   |   |   GAIN SENSE 2

*                       |   |   |   |   |   |   |   |

.SUBCKT INA128          1   2   3   4   5   8   9  10

*

***** A1_128 SUB-CIRCUIT

* CONNECTIONS:          NON-INVERTING INPUT

*                       |   INVERTING INPUT

*                       |   |   POSITIVE POWER SUPPLY

*                       |   |   |   NEGATIVE POWER SUPPLY

*                       |   |   |   |   OUTPUT

*                       |   |   |   |   |

X1                     15  17   3   4  11   A1_128

*

***** A2_128 SUB-CIRCUIT

* CONNECTIONS:          NON-INVERTING INPUT

*                       |   INVERTING INPUT

*                       |   |   POSITIVE POWER SUPPLY

*                       |   |   |   NEGATIVE POWER SUPPLY

*                       |   |   |   |   OUTPUT

*                       |   |   |   |   |

X2                     15  16   3   4  12   A2_128

*

***** A3_128 SUB-CIRCUIT

* CONNECTIONS:          NON-INVERTING INPUT

*                       |   INVERTING INPUT

*                       |   |   POSITIVE POWER SUPPLY

*                       |   |   |   NEGATIVE POWER SUPPLY

*                       |   |   |   |   OUTPUT

*                       |   |   |   |   |

X3                     14  13   3   4   5   A3_128

*

R1    11  13   40.0000K

R2    13   5   39.996K

R3    12  14   40.0000K

R4    14   8   40.0000K

CIN   13  14   4.0000PF

*

R1FB   9  11   25.000K

CC1   17  11   5.0000PF

R2FB  10  12   25.000K

CC2   16  12   5.0000PF

CG1    9   0   10.0000PF

CG2   10   0   8.0000PF

*

RCE   17   9   20G

*

I1     3  16  DC  20.00E-6

I2     3  17  DC  20.00E-6

IB1CAN 3   1  DC  40.00E-9

IB2CAN 3   2  DC  40.00E-9

Ibal   0   4  DC  60.0E-6

*

D1    15  17      DX

D2    15  16      DX

*

Q1    16   1  10  QX

Q2    17   2   9  QX

*

V1     3  15  DC  1.700

*

.MODEL DX D(IS=1.0E-24)

.MODEL QX NPN(IS=800.0E-18 BF=500)

.ENDS

*

* A1_128 operational amplifier "macromodel" subcircuit

* created using Parts release 6.3a on 11/18/96 at 14:19

* Parts is a MicroSim product.

*

* connections:   non-inverting input

*                | inverting input

*                | | positive power supply

*                | | | negative power supply

*                | | | | output

*                | | | | |

.subckt A1_128   1 2 3 4 5

*

  c1   11 12 2.887E-12

  c2    6  7 10.00E-12

  css  10 99 1.000E-30

  dc    5 53 dx

  de   54  5 dx

  dlp  90 91 dx

  dln  92 90 dx

  dp    4  3 dx

  egnd 99  0 poly(2) (3,0) (4,0) 0 .5 .5

  fb    7 99 poly(5) vb vc ve vlp vln 0 79.58E6 -80E6 80E6 80E6 -80E6

  ga    6  0 11 12 1.257E-3

  gcm   0  6 10 99 125.7E-12

  iss   3 10 dc 50.00E-6

  hlim 90  0 vlim 1K

  j1   11  2 10 jx

  j2   12  1 10 jx

  r2    6  9 100.0E3

  rd1   4 11 795.8

  rd2   4 12 795.8

  ro1   8  5 10

  ro2   7 99 10

  ip 	3  4 dc 120u

  rp    3  4 3.00E6

  rss  10 99 4.000E6

  vb    9  0 dc 0

  vc    3 53 dc 1.5

  ve   54  4 dc .9

  vlim  7  8 dc 0

  vlp  91  0 dc 14

  vln   0 92 dc 14

.model dx D(Is=800.0E-18)

.model jx PJF(Is=15.00E-12 Beta=31.58E-3 Vto=-1)

.ends

* A2_128 operational amplifier "macromodel" subcircuit

* created using Parts release 6.3a on 11/18/96 at 14:19

* Parts is a MicroSim product.

*

* connections:   non-inverting input

*                | inverting input

*                | | positive power supply

*                | | | negative power supply

*                | | | | output

*                | | | | |

.subckt A2_128   1 2 3 4 5

*

  c1   11 12 2.887E-12

  c2    6  7 10.00E-12

  css  10 99 1.000E-30

  dc    5 53 dx

  de   54  5 dx

  dlp  90 91 dx

  dln  92 90 dx

  dp    4  3 dx

  egnd 99  0 poly(2) (3,0) (4,0) 0 .5 .5

  fb    7 99 poly(5) vb vc ve vlp vln 0 79.58E6 -80E6 80E6 80E6 -80E6

  ga    6  0 11 12 1.257E-3

  gcm   0  6 10 99 125.7E-12

  iss   3 10 dc 50.00E-6

  hlim 90  0 vlim 1K

  j1   11  2 10 jx

  j2   12  1 10 jx

  r2    6  9 100.0E3

  rd1   4 11 795.8

  rd2   4 12 795.8

  ro1   8  5 10

  ro2   7 99 10

  ip    3  4 dc 120u

  rp    3  4 3.00E6

  rss  10 99 4.000E6

  vb    9  0 dc 0

  vc    3 53 dc 1.5

  ve   54  4 dc .9

  vlim  7  8 dc 0

  vlp  91  0 dc 14

  vln   0 92 dc 14

.model dx D(Is=800.0E-18)

.model jx PJF(Is=15.00E-12 Beta=31.58E-3 Vto=-1)

.ends

* A3_128 operational amplifier "macromodel" subcircuit

* created using Parts release 6.3a on 11/18/96 at 14:33

* Parts is a MicroSim product.

*

* connections:   non-inverting input

*                | inverting input

*                | | positive power supply

*                | | | negative power supply

*                | | | | output

*                | | | | |

.subckt A3_128   1 2 3 4 5

*

  c1   11 12 2.730E-12

  c2    6  7 15.00E-12

  dc    5 53 dx

  de   54  5 dx

  dlp  90 91 dx

  dln  92 90 dx

  dp    4  3 dx

  egnd 99  0 poly(2) (3,0) (4,0) 0 .5 .5

  fb    7 99 poly(5) vb vc ve vlp vln 0 163.2E6 -160E6 160E6 160E6 -160E6

  ga    6  0 11 12 122.5E-6

  gcm   0  6 10 99 12.25E-12

  iee  10  4 dc 63.95E-6

  hlim 90  0 vlim 1K

  q1   11  2 13 qx

  q2   12  1 14 qx

  r2    6  9 100.0E3

  rc1   3 11 8.162E3

  rc2   3 12 8.162E3

  re1  13 10 7.327E3

  re2  14 10 7.327E3

  ree  10 99 3.127E6

  ro1   8  5 10

  ro2   7 99 10

  ip	3  4 dc 220u

  rp 	3  4 1.87E6

  vb    9  0 dc 0

  vc    3 53 dc 1.500

  ve   54  4 dc 1.400

  vlim  7  8 dc 0

  vlp  91  0 dc 5

  vln   0 92 dc 14

.model dx D(Is=800.0E-18)

.model qx NPN(Is=800.0E-18 Bf=318.8)

.ends

.ENDS INA128

*

*
