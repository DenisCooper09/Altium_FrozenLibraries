*
* Diode Model Produced by Altium Ltd
* Date:  3-May-2004
*
* Manufacturer: Renesas
* Component Name: HDSP-7408
*
* Parameters derived from information available in data sheet.
*
*                 common-cathode
*                 |  anode-PLUS
*                 |  |  anode-MINUS
*                 |  |  |  common-cathode
*                 |  |  |  |  anode-DP
*                 |  |  |  |  |  anode-c
*                 |  |  |  |  |  |  anode-b
*                 |  |  |  |  |  |  |
.SUBCKT HDSP_7408 1  2  3  6  7  8  9

DPLUS1  2  1  dHDSP_7408
DMINUS1 3  1  dHDSP_7408
DB1     9  1  dHDSP_7408
DC1     8  1  dHDSP_7408
DDP1    7  1  dHDSP_7408

DPLUS2  2  6  dHDSP_7408
DMINUS2 3  6  dHDSP_7408
DB2     9  6  dHDSP_7408
DC2     8  6  dHDSP_7408
DDP2    7  6  dHDSP_7408

.MODEL dHDSP_7408 D
+ (
+    IS = 2.77296438E-23
+    N  = 1.39205436
+    RS = 25.13253104
+    BV = 45.00000000
+    IBV = 100u
+ )

.ENDS HDSP_7408
