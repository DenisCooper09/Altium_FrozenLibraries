* EL2186/EL2286 Macromodel
* Revision A, March 1995
* AC characteristics used Cin- (pin 2) = 0 pF; Rf = Rg = 750 ohms
*
* Connections:        +input
*                     |   -input
*                     |   |   +Vsupply
*                     |   |   |   -Vsupply
*                     |   |   |   |   output
*                     |   |   |   |   |
.subckt EL2186        3   2   7   4   6
*
* Input Stage
*
e1  10 0 3 0 1.0
vis 10 9 0V
h2   9 12 vxx 1.0
r1   2 11 400
l1  11  12 25nH
iinp 3  0 1.5uA
iinm 2  0 3uA
r12  3  0 2Meg
*
* Slew Rate Limiting
*
h1 13  0 vis 600
r2 13 14 1K
d1 14  0  dclamp
d2  0 14  dclamp
*
* High Frequency Pole
*
e2 30 0 14 0 0.00166666666
l3 30 17 150nH
c5 17 0 0.8pF
r5 17 0 165
*
* Transimpedance Stage
*
g1 0 18 17 0 1.0
rol 18 0 450K
cdp 18 0 0.675pF
*
* Output Stage
*
q1 4 18 19 qp
q2 7 18 20 qn
q3 7 19 21 qn
q4 4 20 22 qp
r7 21 6  4
r8 22 6  4
ios1 7 19 1mA
ios2 20 4 1mA
*
* Supply Current
*
ips 7 4 0.2mA
*
* Error Terms
*
ivos 0 23 0.2mA
vxx 23  0 0V
e4  24 0 3 0 1.0
e5  25 0 7 0 1.0
e6  26 0 4 0 -1.0
r9  24 23 316
r10 25 23 3.2K
r11 26 23 3.2K
*
* Models
*
.model qn npn(is=5e-15 bf=200 tf=0.01nS)
.model qp pnp(is=5e-15 bf=200 tf=0.01nS)
.model dclamp d(is=1e-30 ibv=0.266 bv=0.71v n=4)
.ends
