*
* Diode Model Produced by Altium Ltd
* Date:  7-Apr-2004
*
* Manufacturer: Agilent
* Component Name: HDSP-5737
*
* Parameters derived from information available in data sheet.
*
*                 cathode-c
*                 |  anode-c,d
*                 |  |  cathode-b
*                 |  |  |  anode-a,b, DP
*                 |  |  |  |  cathode DP
*                 |  |  |  |  |  cathode-a
*                 |  |  |  |  |  |  anode-a,b, DP
*                 |  |  |  |  |  |  |  anode-c,d
*                 |  |  |  |  |  |  |  |  cathode-d
*                 |  |  |  |  |  |  |  |  |
*                 |  |  |  |  |  |  |  |  |
.SUBCKT HDSP_5737 1  2  3  4  5  6  7  8  9

DA1  4 6 dHDSP_5737
DA2  7 6 dHDSP_5737

DB1  4 3 dHDSP_5737
DB2  7 3 dHDSP_5737

DC1  2 1 dHDSP_5737
DC2  8 1 dHDSP_5737

DD1  2 9 dHDSP_5737
DD2  8 9 dHDSP_5737

DDP1 4 5 dHDSP_5737
DDP2 7 5 dHDSP_5737

.MODEL dHDSP_5737 D
+ (
+     IS = 8.07922028E-13
+      N = 3.08151986
+     RS = 5.65168121
+     BV = 2.25
+    IBV = 100u
+ )

.ENDS HDSP_5737
