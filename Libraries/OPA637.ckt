* OPA637 OPERATIONAL AMPLIFIER "MACROMODEL" SUBCIRCUIT

* CREATED USING PARTS RELEASE 4.03 ON 10/04/90 AT 11:11

*

* REV.B   5/22/91 TK

* REV.C    1/8/93 Changed nodes on J2 BCB

*  ------------------------------------------------------------------------

* |  NOTICE: THE INFORMATION PROVIDED HEREIN IS BELIEVED TO BE RELIABLE;   |

* |  HOWEVER; BURR-BROWN ASSUMES NO RESPONSIBILITY FOR INACCURACIES OR     |

* |  OMISSIONS.  BURR-BROWN ASSUMES NO RESPONSIBILITY FOR THE USE OF THIS  |

* |  INFORMATION, AND ALL USE OF SUCH INFORMATION SHALL BE ENTIRELY AT     |

* |  THE USER'S OWN RISK.  NO PATENT RIGHTS OR LICENSES TO ANY OF THE      |

* |  CIRCUITS DESCRIBED HEREIN ARE IMPLIED OR GRANTED TO ANY THIRD PARTY.  |

* |  BURR-BROWN DOES NOT AUTHORIZE OR WARRANT ANY BURR-BROWN PRODUCT FOR   |

* |  USE IN LIFE-SUPPORT DEVICES AND/OR SYSTEMS.                           |

*  ------------------------------------------------------------------------

*

* CONNECTIONS:   NON-INVERTING INPUT

*                | INVERTING INPUT

*                | | POSITIVE POWER SUPPLY

*                | | | NEGATIVE POWER SUPPLY

*                | | | | OUTPUT

*                | | | | |

.SUBCKT OPA637   1 2 3 4 5

*

C1   11 12 8.221E-12

C2    6  7 3.600E-12

DC    5 53 DX

DE   54  5 DX

DLP  90 91 DX

DLN  92 90 DX

DP    4  3 DX

EGND 99  0 POLY(2) (3,0) (4,0) 0 .5 .5

FB    7 99 POLY(5) VB VC VE VLP VLN 0 552.6E6 -20E6 20E6 20E6 -20E6

GA    6  0 11 12 1.810E-3

GCM   0  6 10 99 2.868E-9

ISS   3 10 DC 486.0E-6

HLIM 90  0 VLIM 1K

J1   11  2 10 JX

J2   12  1 10 JX

R2    6  9 100.0E3

RD1   4 11 552.6

RD2   4 12 552.6

RO1   8  5 54

RO2   7 99 1

RP    3  4 4.286E3

RSS  10 99 411.5E3

VB    9  0 DC 0

VC    3 53 DC 2.700

VE   54  4 DC 2.700

VLIM  7  8 DC 0

VLP  91  0 DC 55

VLN   0 92 DC 55

.MODEL DX D(IS=800.0E-18)

.MODEL JX PJF(IS=500.0E-15 BETA=3.37E-3 VTO=-1)

.ENDS


