*
* Diode Model Produced by Altium Ltd
* Date:  11-Mar-2004
*
* Manufacturer: Agilent
* Component Name: HDSM-550G
*
* Parameters derived from information available in data sheet.
*
*                 STOP1/a(1&3)
*                 |  STOP2/b(1&3)
*                 |  |  COOK1/c(1&3)
*                 |  |  |  COOK2/d(1&3)
*                 |  |  |  |  START1/e(1&3)
*                 |  |  |  |  |  START2/f(1&3)
*                 |  |  |  |  |  |  TIME1/g(1&3)
*                 |  |  |  |  |  |  |  TIME2/a(2&4)
*                 |  |  |  |  |  |  |  |  R/b(2&4)
*                 |  |  |  |  |  |  |  |  |  COLON1/c(2&4)
*                 |  |  |  |  |  |  |  |  |  |  COLON2/d(2&4)
*                 |  |  |  |  |  |  |  |  |  |  |  SET1/e(2&4)
*                 |  |  |  |  |  |  |  |  |  |  |  |  SET2/f(2&4)
*                 |  |  |  |  |  |  |  |  |  |  |  |  |  HR/g(2&4)
*                 |  |  |  |  |  |  |  |  |  |  |  |  |  |  -/CLK1/CLEAN1
*                 |  |  |  |  |  |  |  |  |  |  |  |  |  |  |  -/CLK2/CLEAN2
*                 |  |  |  |  |  |  |  |  |  |  |  |  |  |  |  |  K1
*                 |  |  |  |  |  |  |  |  |  |  |  |  |  |  |  |  |  K2
*                 |  |  |  |  |  |  |  |  |  |  |  |  |  |  |  |  |  |  K3
*                 |  |  |  |  |  |  |  |  |  |  |  |  |  |  |  |  |  |  |
.SUBCKT HDSM_550G 1  2  3  4  5  6  7  8  9  10 11 12 13 14 15 16 17 18 19

D1   1 19 dHDSM_550G
D2   1 18 dHDSM_550G
D3   1 17 dHDSM_550G

D4   2 19 dHDSM_550G
D5   2 18 dHDSM_550G
D6   2 17 dHDSM_550G

D7   3 19 dHDSM_550G
D8   3 18 dHDSM_550G
D9   3 17 dHDSM_550G

D10  4 19 dHDSM_550G
D11  4 18 dHDSM_550G
D12  4 17 dHDSM_550G

D13  5 19 dHDSM_550G
D14  5 18 dHDSM_550G
D15  5 17 dHDSM_550G

D16  6 19 dHDSM_550G
D17  6 18 dHDSM_550G
D18  6 17 dHDSM_550G

D19  7 19 dHDSM_550G
D20  7 18 dHDSM_550G
D21  7 17 dHDSM_550G

D22  8 19 dHDSM_550G
D23  8 18 dHDSM_550G
D24  8 17 dHDSM_550G

D25  9 19 dHDSM_550G
D26  9 18 dHDSM_550G
D27  9 17 dHDSM_550G

D28 10 19 dHDSM_550G
D29 10 18 dHDSM_550G
D30 10 17 dHDSM_550G

D31 11 19 dHDSM_550G
D32 11 18 dHDSM_550G
D33 11 17 dHDSM_550G

D34 12 19 dHDSM_550G
D35 12 18 dHDSM_550G
D36 12 17 dHDSM_550G

D37 13 19 dHDSM_550G
D38 13 18 dHDSM_550G
D39 13 17 dHDSM_550G

D40 14 19 dHDSM_550G
D41 14 18 dHDSM_550G
D42 14 17 dHDSM_550G

D43 15 18 dHDSM_550G
D44 15 17 dHDSM_550G

D45 16 18 dHDSM_550G
D46 16 17 dHDSM_550G

.MODEL dHDSM_550G D
+ (
+     IS = 6.02519230E-43
+      N = 0.80350536
+     RS = 9.92584724
+     BV = 5.5
+    IBV = 100u
+ )

.ENDS HDSM_550G
