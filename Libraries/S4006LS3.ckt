*S4006LS3 MCE 5-22-97
*Ref: Teccor general catalog 95/96
*400V 6A pkg:TO-220 2,3,1
.SUBCKT S4006LS3 1 2 3
*    TERMINALS:  A G K
QP  6 4 1  POUT OFF
QN  4 6 5  NOUT OFF
RF  6 4    160MEG
RR  1 4    107MEG
RGK 6 5    150
RG  2 6    9.07
RK  3 5    0.133
DF  6 4    ZF
DR  1 4    ZR
DGK 6 5    ZGK
.MODEL ZF   D (IS=2.4F IBV=500N BV=400)
.MODEL ZR   D (IS=2.4F IBV=500N BV=400)
.MODEL ZGK  D (IS=2.4F IBV=500N BV=6)
.MODEL POUT PNP (IS=2.4P BF=1 CJE=1.07N TF=22.1U)
.MODEL NOUT NPN (IS=2.4P BF=100 RC=0.533 CJE=5.36N CJC=1.07N TF=1.47U)
.ENDS
