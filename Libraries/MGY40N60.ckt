*MGY40N60  MCE  C G E  6/3/97
*Ref: Motorola TMOS Databook Q2/96
*600V 66A 45ns pkg:TO-247 2,1,3
.SUBCKT MGY40N60 71 72 74
*     TERMINALS:  C  G  E
Q1  83 81 85     QOUT OFF
M1  81 82 83 83  MFIN L=1U W=1U
DSD 83 81  DO
DBE 85 81  DE
RC  85 71  19.5M
RE  83 73  1.95M
RG  72 82  23.1
CGE 82 83  6.8N
EGD 91  0 82 81  1
VFB 93  0  0
FFB 82 81  VFB  1
CGD 92 93  3.04N
R1  92  0  1
D1  91 92  DLIM
DHV 94 93  DR
R2  91 94  1
D2  94  0  DLIM
LE  73 74  13N
DLV 94 95  DR 13
RLV 95  0  1
ESD 96 93  POLY(1) 83 81 19  1
MLV 95 96 93 93  SW
.MODEL SW NMOS (LEVEL=3 VTO=0 KP=5)
.MODEL QOUT PNP (IS=1.96E-16 NF=1.2 BF=5.1 CJE=7.43N TF=45N XTB=1.3)
.MODEL MFIN NMOS (LEVEL=3 VMAX=400K THETA=40M ETA=2.01M VTO=6 KP=0.932)
.MODEL DR D (IS=1.96E-17 CJO=217P VJ=1 M=0.82)
.MODEL DO D (IS=1.96E-17 BV=599 CJO=4.39N VJ=1 M=0.7)
.MODEL DE D (IS=1.96E-17 BV=25 N=2)
.MODEL DLIM D (IS=100N)
.ENDS
* Origin: Mceigbts.lib
