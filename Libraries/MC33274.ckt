* MC33274 operational amplifier
*"macromodel" subcircuit
*
* connections:
*    1 -  non-inverting input
*    2 -  inverting input
*    3 -  positive power supply
*    4 -  negative power supply
*    5 -  output
*
.subckt MC33274  1 2 3 4 5
*
  c1   11 12 1.926E-12
  c2    6  7 5.500E-12
  cee  10 99 1.650E-12
  dc    5 53 dx
  de   54  5 dx
  dlp  90 91 dx
  dln  92 90 dx
  dp    4  3 dx
*egnd 99  0 poly(2) (3,0) (4,0) 0 .5 .5
  begnd 99  0 v=.5*v(3,0)+.5*v(4,0)
*fb    7 99 poly(5) vb vc ve vlp vln 0 17.54E6 -20E6 20E6 20E6 -20E6
  bfb   7 99 i=17.54E6*i(vb)-20E6*i(vc)+20E6*i(ve)+20E6*i(vlp)-20E6*i(vln)
  ga    6  0 11 12 190.1E-6
  gcm   0  6 10 99 1.901E-9
  iee   3 10 dc 72.10E-6
  hlim 90  0 vlim 1K
  q1   11  2 13 qx
  q2   12  1 14 qx
  r2    6  9 100.0E3
  rc1   4 11 5.261E3
  rc2   4 12 5.261E3
  re1  13 10 4.500E3
  re2  14 10 4.500E3
  ree  10 99 2.774E6
  ro1   8  5 35
  ro2   7 99 30
  rp    3  4 29.90E3
  vb    9  0 dc 0
  vc    3 53 dc .9
  ve   54  4 dc .3
  vlim  7  8 dc 0
  vlp  91  0 dc 37
  vln   0 92 dc 37
  desd1  1  3 dx
  desd2  2  3 dx
.model dx D(Is=800.0E-18)
.model qx PNP(Is=800.0E-18 Bf=119.2)
.ends
*$
