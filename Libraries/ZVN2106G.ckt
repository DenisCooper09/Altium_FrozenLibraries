*ZETEX   ZVN2106G Mosfet Spice Subcircuit        Last revision  3/86
*
.SUBCKT ZVN2106G 3 4 5
*                D G S
M1 3 2 5 5 MN2106
RG 4 2 120
RL 3 5 1.2E8
D1 5 3 DN2106
*
.MODEL MN2106 NMOS VTO=1.512 RS=0.772 RD=0.449 IS=1E-15 KP=0.653
+CGSO=45E-12 CGDO=15E-12 CBD=63E-12 PB=1 LAMBDA=1.95E-3
*
.MODEL DN2106 D IS=2.25E-12 RS=0.404
.ENDS ZVN2106G
*
*                          (C)  1991 ZETEX PLC
*
*   The copyright in this model  and  the design embodied belong to
*   Zetex PLC ("Zetex"). It is supplied free of charge by Zetex for
*   the purpose  of research  and design  and may be used or copied
*   intact (including this notice) for that purpose only. All other
*   rights  are  reserved.  The model  is believed  accurate but no
*   condition or warranty as to its  merchantability or fitness for
*   purpose  is  given  and  no liability  in respect of any use is
*   accepted by Zetex PLC, its distributors or agent.
*
*
*   Zetex PLC, Fields New Road, Chadderton, Oldham  OL9 8NP
