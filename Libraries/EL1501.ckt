* lf156 model courtesy of Linear Technology Corp.
* EL1501 Macromodel
* Revision A,  April 1996
*******************************************************************************
**
* Applications Hint. Pins 4, 5, 6, 7, 14, 15, 16, & 17 must be connected to
* ground (node 0) for proper operation. Use resistors whose value is 1e-6
ohms.
*
******************************************************************************
* Connections:
* Vin-, Dr+
*     |   Vout, Dr+
*     |      |    V-
*     |      |     |    Gnd
*     |      |     |      |   Gnd
*     |      |     |      |     |    Gnd
*.    |      |     |      |     |       |     Gnd
*     |      |     |      |     |       |        |    Vin+, Dr+
*     |      |     |      |     |       |        |       |   Vout, Rcvr+
*     |      |     |      |     |       |        |       |         |  Vin-,
Rcvr+
*     |      |     |      |     |       |        |       |         |       |

*     1     2    3     4    5      6      7     8         9    10
*
*    Vin-, Rcvr-
*        |   Vout, Rcvr-
*        |         |   Vin+, Dr-
*        |         |      |   Gnd
*        |         |      |      |    Gnd
*        |         |      |      |        |   Gnd
*        |         |      |      |        |       |   Gnd
*        |         |      |      |        |       |     |    V+
*        |         |      |      |        |       |     |      |    Vout, Dr-
*        |         |      |      |        |       |     |      |        |
 Vin-,Dr-
*        |         |      |      |        |       |      |     |        |
     |
*      11      12   13  14      15    16   17   18   19       20
.subckt EL1501     1 2 3 4 5 6 7 8 9 10 11 12 13 14 15 16 17 18 19 20
*
*******************
* Driver+ (Amplifier A)
*
e1a  30 0 8 0 1.0
visa  30 43 0V
h2a   43 44 v1a 1.0
r1a     1 45  25
l1a    45 44 2.5nH
i1a      8   0 1uA
i2a      1   0 5uA
h1a   46  0 visa 600
r2a   46 31 1K
d1a   31  0   dclamp
d2a    0  31  dclamp
e2a   32 0 31 0 0.0016666
l3a   32 33 0.5uH
c1a   33  0 1pF
r5a   33 0 200
g1a    0 34 33 0 1.0
rola  34  0 2Meg
c2a   34 0 3pF
q1a  3 34 35 qp
q2a 18 34 36 qn
q3a 18 35 37 qn
q4a  3 36 38 qp
r7a   37 2  2
r8a   38 2  2
i3a   18 35 3.3mA
i4a   36  3 3.3mA
ivosa 0 42 2mA
v1a   42  0 0V
********
* Driver- (Amplifier B)
*
e1b  50 0 13 0 1.0
visb  50 63 0V
h2b  63 64 v1b 1.0
r1b    20 65  25
l1b    65 64 2.5nH
i1b      13   0 1uA
i2b      20   0 5uA
h1b   66  0 visb 600
r2b   66 51 1K
d1b   51  0   dclamp
d2b    0  51  dclamp
e2b   52 0 51 0 0.0016666
l3b   52 53 0.5uH
c1b   53  0 1pF
r5b   53 0 200
g1b    0 54 53 0 1.0
rolb  54  0 2Meg
c2b   54 0 3pF
q1b  3 54 55 qp
q2b 18 54 56 qn
q3b 18 55 57 qn
q4b  3 56 58 qp
r7b   57 19  2
r8b   58 19  2
i3b   18 55  3.3mA
i4b   56   3  3.3mA
ivosb  0 62 2mA
v1b  62  0 0V
********************
* Receiver+ (Amplifier C)
*
rpin1 4   5 1e-6
rpin2 5   6 1e-6
rpin3 6   7 1e-6
rpin4 7  14 1e-6
e1c   70 0 7 0 1.0
visc  70 83 0V
h2c   83 84 v1b 1.0
r1c   10 85  25
l1c   85 84 2.5nH
i1c    7  0 1uA
i2c   10  0 5uA
h1c   86  0 visc 600
r2c   86 71 1K
d1c   71  0 dclamp
d2c    0  71  dclamp
e2c   72 0 71 0 0.0016666
l3c   72 73 0.5uH
c1c   73  0 1pF
r5c   73 0 200
g1c    0 74 73 0 1.0
rolc  74  0 2Meg
c2c   74 0 4.1pF
q1c   3 74 75 qp
q2c  18 74 76 qn
q3c  18 75 77 qn
q4c   3 76 78 qp
r7c   77 9  2
r8c   78 9  2
i3c   18 75  3.3mA
i4c   76  3  3.3mA
ivosc  0 82 2mA
v1c   82  0 0V
**********************
* Receiver- (Amplifier D)
*
rpin5 17 16 1e-6
rpin6 16 15 1e-6
rpin7 15 14 1e-6
e1d   90 0 14 0 1.0
visd  90 103 0V
h2d   103 104 v1d 1.0
r1d   11 105  25
l1d   105 104 2.5nH
i1d    7  0 1uA
i2d   11  0 5uA
h1d   106  0 visd 600
r2d   106 91 1K
d1d   91  0 dclamp
d2d    0 91 dclamp
e2d   92 0 91 0 0.0016666
l3d   92 93 0.5uH
c1d   93  0 1pF
r5d   93 0 200
g1d    0 94 93 0 1.0
rold  94  0 2Meg
c2d   94 0 4.1pF
q1d   3 94 95 qp
q2d  18 94 96 qn
q3d  18 95 97 qn
q4d   3 96 98 qp
r7d   97 12  2
r8d   98 12  2
i3d   18 95  3.3mA
i4d   96  3  3.3mA
ivosd  0 102 2mA
v1d   102  0 0V
*
* Models
*
.model qn npn(is=5e-15 bf=350 tf=0.1nS)
.model qp pnp(is=5e-15 bf=350 tf=0.1nS)
.model dclamp d(is=1e-30 ibv=0.266 bv=1.9 n=4)
.ends
