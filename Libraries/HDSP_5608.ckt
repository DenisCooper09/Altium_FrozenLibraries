*
* Diode Model Produced by Altium Ltd
* Date:  6-Apr-2004
*
* Manufacturer: Agilent
* Component Name: HDSP-5608
*
* Parameters derived from information available in data sheet.
*
*                 anode-c
*                 |  cathode-c, d
*                 |  |  anode-b
*                 |  |  |  cathode-a, b, DP
*                 |  |  |  |  anode-DP
*                 |  |  |  |  |  anode-a
*                 |  |  |  |  |  |  cathode-a, b, DP
*                 |  |  |  |  |  |  |  cathode-c, d
*                 |  |  |  |  |  |  |  |  anode-d
*                 |  |  |  |  |  |  |  |  |
.SUBCKT HDSP_5608 1  2  3  4  5  6  7  8  9

DA1   6  4 dHDSP_5608
DB1   3  4 dHDSP_5608
DDP1  5  4 dHDSP_5608

DA2   6  7 dHDSP_5608
DB2   3  7 dHDSP_5608
DDP2  5  7 dHDSP_5608

DC1   1  2 dHDSP_5608
DD1   9  2 dHDSP_5608

DC2   1  8 dHDSP_5608
DD2   9  8 dHDSP_5608

.MODEL dHDSP_5608 D
+ (
+     IS = 1.61114016E-27
+      N = 1.30291189
+     RS = 12.83456794
+     BV = 50
+    IBV = 100u
+ )

.ENDS HDSP_5608
