*
* Diode Model Produced by Altium Ltd
* Date:  10-Mar-2004
*
* Manufacturer: Agilent
* Component Name: HDSP-F508
*
* Parameters derived from information available in data sheet.
*
*                 common-cathode
*                 |  anode-PLUS
*                 |  |  anode-MINUS
*                 |  |  |  common-cathode
*                 |  |  |  |  anode-DP
*                 |  |  |  |  |  anode-c
*                 |  |  |  |  |  |  anode-b
*                 |  |  |  |  |  |  |
.SUBCKT HDSP_F508 1  2  3  6  7  8  9

DPLUS1  2 1 dHDSP_F508
DMINUS1 3 1 dHDSP_F508
DB1     9 1 dHDSP_F508
DC1     8 1 dHDSP_F508
DDP1    7 1 dHDSP_F508

DPLUS2  2 6 dHDSP_F508
DMINUS2 3 6 dHDSP_F508
DB2     9 6 dHDSP_F508
DC2     8 6 dHDSP_F508
DDP2    7 6 dHDSP_F508

.MODEL dHDSP_F508 D
+ (
+     IS = 1.61114016E-27
+      N = 1.30291189
+     RS = 12.83456794
+     BV = 50
+    IBV = 100u
+ )

.ENDS HDSP_F508
