*MC33171 OPERATIONAL AMPLIFIER "MACROMODEL" SUBCIRCUIT
*
* Connections:
*                Non-Inverting Input
*                | Inverting Input
*                | | Positive Power Supply
*                | | | Negative Power Supply
*                | | | | Output
*                | | | | |
.SUBCKT MC33171  1 2 3 4 5
  C1   11 12 8.660E-12
  C2    6  7 5.500E-12
  CEE  10 99 4.976E-12
  DC    5 53 DX
  DE   54  5 DX
  DLP  90 91 DX
  DLN  92 90 DX
  DP    4  3 DX
  EGND 99  0 POLY(2) (3,0) (4,0) 0 .5 .5
  FB    7 99 POLY(5) VB VC VE VLP VLN 0 89.31E6
  + -90E6 90E6 90E6 -90E6
  GA    6  0 11 12 62.20E-6
  GCM   0  6 10 99 1.967E-9
  IEE   3 10 DC 22.04E-6
  HLIM 90  0 VLIM 1K
  Q1   11  2 13 QX
  Q2   12  1 14 QX
  R2    6  9 100.0E3
  RC1   4 11 16.08E3
  RC2   4 12 16.08E3
  RE1  13 10 13.70E3
  RE2  14 10 13.70E3
  REE  10 99 9.074E6
  RO1   8  5 110
  RO2   7 99 90
  RP    3  4 291.3E3
  VB    9  0 DC 0
  VC    3 53 DC .8
  VE   54  4 DC .8
  VLIM  7  8 DC 0
  VLP  91  0 DC 10
  VLN   0 92 DC 10
  DESD1  1  3 DX
  DESD2  2  3 DX
.MODEL DX D(IS=800.0E-18)
.MODEL QX PNP(IS=800.0E-18 BF=550)
.ENDS MC33171
