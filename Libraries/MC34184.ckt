*MC34184 OPERATIONAL AMPLIFIER "MACROMODEL" SUBCIRCUIT
*
* Connections:
*                Non-Inverting Input
*                | Inverting Input
*                | | Positive Power Supply
*                | | | Negative Power Supply
*                | | | | Output
*                | | | | |
.SUBCKT MC34184  1 2 3 4 5
  C1   11 12 1.061E-12
  C2    6  7 5.000E-12
  CSS  10 99 4.000E-12
  DC    5 53 DX
  DE   54  5 DX
  DLP  90 91 DX
  DLN  92 90 DX
  DP    4  3 DX
*EGND 99  0 POLY(2) (3,0) (4,0) 0 .5 .5
  BEGND 99  0 V=.5*v(3,0)+.5*v(4,0)
*FB    7 99 POLY(5) VB VC VE VLP VLN 0 4.775E6 -5E6 5E6 5E6 -5E6
  BFB    7 99 I=4.775E6*I(VB)-5E6*I(VC)+5E6*I(VE)+5E6*I(VLP)-5E6*I(VLN)
  GA    6  0 11 12 125.7E-6
  GCM   0  6 10 99 6.298E-9
  ISS   3 10 DC 90.00E-6
  HLIM 90  0 VLIM 1K
  J1   11  2 10 JX
  J2   12  1 10 JX
  R2    6  9 100.0E3
  RD1   4 11 7.958E3
  RD2   4 12 7.958E3
  RO1   8  5 100
  RO2   7 99 100
  RP    3  4 285.7E3
  RSS  10 99 2.222E6
  VB    9  0 DC 0
  VC    3 53 DC 1.66
  VE   54  4 DC 1.66
  VLIM  7  8 DC 0
  VLP  91  0 DC 10
  VLN   0 92 DC 10
.MODEL DX D(IS=800.0E-18)
.MODEL JX PJF(IS=1.500E-12 BETA=175.5E-6
+ VTO=-1)
.ENDS MC34184
