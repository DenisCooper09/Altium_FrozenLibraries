*
* Diode Model Produced by Altium Ltd
* Date:  10-Mar-2004
*
* Manufacturer: Agilent
* Component Name: HDSP-F308
*
* Parameters derived from information available in data sheet.
*
*                 common-cathode
*                 |  anode-PLUS
*                 |  |  anode-MINUS
*                 |  |  |  common-cathode
*                 |  |  |  |  anode-DP
*                 |  |  |  |  |  anode-c
*                 |  |  |  |  |  |  anode-b
*                 |  |  |  |  |  |  |
.SUBCKT HDSP_F308 1  2  3  6  7  8  9

DPLUS1  2 1 dHDSP_F308
DMINUS1 3 1 dHDSP_F308
DB1     9 1 dHDSP_F308
DC1     8 1 dHDSP_F308
DDP1    7 1 dHDSP_F308

DPLUS2  2 6 dHDSP_F308
DMINUS2 3 6 dHDSP_F308
DB2     9 6 dHDSP_F308
DC2     8 6 dHDSP_F308
DDP2    7 6 dHDSP_F308

.MODEL dHDSP_F308 D
+ (
+     IS = 6.04055825E-18
+      N = 1.90788337
+     RS = 23.52447762
+     BV = 40
+    IBV = 100u
+ )

.ENDS HDSP_F308
