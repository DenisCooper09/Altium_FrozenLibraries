*
* Diode Model Produced by Altium Ltd
* Date:  7-Apr-2004
*
* Manufacturer: Agilent
* Component Name: 5082-7656
*
* Parameters derived from information available in data sheet.
*
*                  cathode-d
*                  |  anode-d
*                  |  |  cathode-c
*                  |  |  |  cathode-e
*                  |  |  |  |  anode-e
*                  |  |  |  |  |  anode-c
*                  |  |  |  |  |  |  anode-DP
*                  |  |  |  |  |  |  |  cathode-DP
*                  |  |  |  |  |  |  |  |  cathode-b
*                  |  |  |  |  |  |  |  |  |  cathode-a
*                  |  |  |  |  |  |  |  |  |  |  anode-a
*                  |  |  |  |  |  |  |  |  |  |  |  anode-b
*                  |  |  |  |  |  |  |  |  |  |  |  |
.SUBCKT 5082_7656  1  2  4  5  6  7  8  9  10 11 13 14

DA  13 11 d5082_7656
DB  14 10 d5082_7656
DC   7  4 d5082_7656
DD   2  1 d5082_7656
DE   6  5 d5082_7656
DDP  8  9 d5082_7656

.MODEL d5082_7656 D
+ (
+     IS = 1.95991353E-12
+      N = 2.90687588
+     RS = 18.38470387
+     BV = 30
+    IBV = 100u
+ )

.ENDS 5082_7656
