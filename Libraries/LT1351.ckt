*//////////////////////////////////////////////////////////////
* LT1351  250µA, 3MHz, 200V/µs Operational Amplifier         //
*//////////////////////////////////////////////////////////////
*
* connections:     non-inverting input
*                  |   inverting input
*                  |   |   positive power supply
*                  |   |   |   negative power supply
*                  |   |   |   |   output
*                  |   |   |   |   |
*                  |   |   |   |   |
.SUBCKT LT1351     3   2   7   4   6
* INPUT
*RC1 7  80 1894.7        ;3.7894E+03
*RC2 7  90 1894.7        ;3.7894E+03

RC1 7  80 1894.7
RC2 7  90 1894.7

Q1  80 2  10 QM1
Q2  90 3  11 QM2
CIN 2  3  2.0000E-12
*INPUT POLE AT 4.5MHZ
*C1  80 90 9.34E-12      ;4.67E-12

C1  80 90 9.34E-12

*RE1 10 12 +3.7709E+03
*RE2 11 12 +3.7709E+03

RE1 10 12  3.7709E+03
RE2 11 12  3.7709E+03

IEE 12 4  2.8000E-03
RE  12 0  7.1428E+04
* INTERMEDIATE
GCM 8  0  12 0  5.2654E-09
GA  8  0  78 0  2.6389E-04
R2  8  0  255E+06
C2  8  0  12.6E-12
DC1 8  7  DM3
DC2 4  8  DM3
*
*POLE AT 20MHZ
*GX1 0  28 90 80 2E-06    ;1E-06
*jg, 30/6/2000: syntax errors corrected.

GX1 0  28 90 80 2E-06

RX1 28 0  1E+06
CX1 28 0  7.69E-15
*POLE AT 45MHZ
GX2 0  38 28 0  1E-06
RX2 38 0  1E+06
CX2 38 0  3.54E-15
*POLE AT 45MHZ
GX3 0  48 38 0  1E-06
RX3 48 0  1E+06
CX3 48 0  3.54E-15
*ZERO AT 4.5MHZ
GX4 0  58 48 0  1E-06
RX4 58 59 1E+06
LX4 59 0  35.4E-03
*POLE AT 9MHZ
GX5 0  68 58 0  1E-06
RX5 68 0 1E+06
CX5 68 0 17.7E-15
*POLE AT 300MHZ
GX6 0  78 68 0  1E-06
RX6 78 0  1E+06
CX6 78 0  .531E-15
*OUTPUT
EB  1  0  8  0  1
RO2 1  6  160
RF  8  99 20E+03
CF  99 6  7.5E-12
*
* CURRENT LIMIT
ECL 18 1  6  1  .103
Q3 7 18 8 QM3
Q4 4 18 8 QM4
*
D3A 131 70 DM3
D3B 13 131 DM3
GPL 8  0  70 7  1.0000E+00
VC  13 6  3.0182E+00
RPLA 7  70 1.0000E+01
RPLB 7  131 1.0000E+03
D4A 60 141 DM3
D4B 141 14  DM3
GNL 8  0  60 4  1.0000E+00
VE  6  14 3.0182E+00
RNLA 60 4  1.0000E+01
RNLB 141 4  1.0000E+03
*
IP  7  4  -.2550E-02
DSUB 4  7  DM2
* MODELS
.MODEL QM1 NPN (IS=8.0000E-16 BF=8.0000E+04)
.MODEL QM2 NPN (IS=8.0621E-16 BF=1.1200E+05)
.MODEL QM3 NPN (IS=8.0000E-16 BF=100)
.MODEL QM4 PNP (IS=8.0000E-16 BF=100)
.MODEL DM1  D   (IS=1.0000E-20)
.MODEL DM2  D   (IS=8.0000E-16 BV=4.3200E+01)
.MODEL DM3  D   (IS=1.0000E-16)
.ENDS LT1351
*
