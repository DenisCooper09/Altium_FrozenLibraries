* OPA603X CURRENT-FEEDBACK AMPLIFIER "CIRCUIT MODEL" SUBCIRCUIT

*

* CREATED USING BLOOD,SWEAT AND TEARS ON 10/12/90 AT 09:03AM

* REV.B   5/23/91

* REV.C   10/20/92 - SYNTAX ERRORS BCB

* REV.D    9/17/97 - Syntax error   SB

*  ------------------------------------------------------------------------

* |  NOTICE: THE INFORMATION PROVIDED HEREIN IS BELIEVED TO BE RELIABLE;   |

* |  HOWEVER; BURR-BROWN ASSUMES NO RESPONSIBILITY FOR INACCURACIES OR     |

* |  OMISSIONS.  BURR-BROWN ASSUMES NO RESPONSIBILITY FOR THE USE OF THIS  |

* |  INFORMATION, AND ALL USE OF SUCH INFORMATION SHALL BE ENTIRELY AT     |

* |  THE USER'S OWN RISK.  NO PATENT RIGHTS OR LICENSES TO ANY OF THE      |

* |  CIRCUITS DESCRIBED HEREIN ARE IMPLIED OR GRANTED TO ANY THIRD PARTY.  |

* |  BURR-BROWN DOES NOT AUTHORIZE OR WARRANT ANY BURR-BROWN PRODUCT FOR   |

* |  USE IN LIFE-SUPPORT DEVICES AND/OR SYSTEMS.                           |

*  ------------------------------------------------------------------------

*

* CONNECTIONS:   NON-INVERTING INPUT

*                | INVERTING INPUT

*                | | POSITIVE POWER SUPPLY

*                | | | NEGATIVE POWER SUPPLY

*                | | | | OUTPUT

*                | | | | |

.SUBCKT  OPA603X 3 4 1 2 5

********************************

.MODEL DCLAMP D

********************************

R0A 3 6 100

R0B 3 7 100

R0EA 10 8 21

R0EB 11 9 21

R1A 10 12 100

R1B 11 13 100

R1EA 14 4 21

R1EB 15 4 21

R2AT 1 16 1213.22365

R2BT 2 17 1200

R3 22 23 16.25

R4A 24 5 3.25

R4B 25 5 3.25

X0A 2 6 8 2 XP4LC

X0B 1 7 9 2 XN4LC

X1A 16 12 14 2 XN4LC

X1B 17 13 15 2 XP4LC

X2A 20 16 18 2 XP4LC

X2B 21 17 19 2 XN4LC

C2B 17 21 0.75PF

X3A 20 20 22 2 XN16HC

X3B 21 21 23 2 XP16HC

X4A1 1 20 24 2 XN16HC

X4A2 1 20 24 2 XN16HC

X4A3 1 20 24 2 XN16HC

X4B1 2 21 25 2 XP16HC

X4B2 2 21 25 2 XP16HC

X4B3 2 21 25 2 XP16HC

X6A1 18 18 26 2 XP16HC

X6A2 18 18 26 2 XP16HC

X6B1 19 19 27 2 XN16HC

X6B2 19 19 27 2 XN16HC

V6A 1 26 0

V6B 27 2 0

FB 1 28 POLY(2) V6A V6B 15UA -0.0025 -0.0025

RB 28 2 500MEG

CB 28 2 350PF

DB1 28 2 DCLAMP

DB2 2 28 DCLAMP

GC 36 37 28 2 0.01

R5A 30 32 21

R5B 31 33 21

R8A 34 36 21

R8B 35 37 21

X5A 10 36 32 2 XP4LC

X5B 11 37 33 2 XN4LC

X8A 1 30 34 2 XN4LC

X8B 2 31 35 2 XP4LC

X9A 1 1 30 2 XN4LC

X9B 2 2 31 2 XP4LC

IS 1 2 290UA

RPS 1 2 21.6K

XSCA 5 22 22 2 XN4LC

XSCB 5 23 23 2 XP4LC

.ENDS OPA603X

.SUBCKT XN4LC 1 2 3 SUB

Q1 4 2 3 SUB N4

RCDC 1 4 250

RCAC 1 5 85

CRC  4 5 1NF

CS   1 0 0.45PF

.MODEL N4 NPN (IS=4.4FA BF=250 VA=100 IKF=14MA BR=0.1
+RE=1.5 RB=200 RBM=75 IRB=22MA RC=0 CJE=2.2PF VJE=0.77 MJE=0.3
+CJC=0.98PF VJC=0.64 MJC=0.425 XCJC=0.2 CCS=0 VJS=0.75 MJS=0
+FC=0.9 TF=65P XTF=20 VTF=10 ITF=300MA TR=1US EG=1.20561 XTB=6M
+XTI=2.33 KF=0.16F)

.ENDS XN4LC

*********************************

.SUBCKT XN16HC 1 2 3 SUB

Q1 4 2 3 SUB N16HC 1

RCDC 1 4 62.5

RCAC 1 5 20

CRC 5 4 100N

CS 1 0 0.80PF

.MODEL N16HC NPN (IS=16FA BF=250 VA=100 IKF=56MA BR=0.1
+RE=187.5M RB=50 RBM=9 IRB=176MA RC=0 CJE=11.2PF VJE=0.77 MJE=0.3
+CJC=2.929PF VJC=0.64 MJC=0.36 XCJC=0.2 CCS=0 VJS=0.75 MJS=0
+FC=0.8 TF=150P XTF=80 VTF=50 ITF=1.6 TR=1US EG=1.20561 XTB=6M
+XTI=2.33  KF=0.16F)

.ENDS XN16HC

*********************************

.SUBCKT XP4LC 1 2 3 SUB

Q1 4 2 3 SUB P4

RCDC 1 4 300

RCAC 1 5 100

CRC  4 5 1NF

CS   1 0 0.54PF

.MODEL P4 PNP (IS=4.4FA BF=100 VA=60 IKF=14MA BR=0.1
+RE=3 RB=100 RBM=15 IRB=1.93MA RC=0 CJE=2PF VJE=0.77 MJE=0.3
+CJC=1.6PF VJC=0.64 MJC=0.425 XCJC=0.21 CCS=0 VJS=0.75 MJS=0
+FC=0.9 TF=150P XTF=20 ITF=160MA TR=1US EG=1.205612 XTB=6M
+XTI=2.33 KF=0.16F)

.ENDS XP4LC

*********************************

.SUBCKT XP16HC 1 2 3 SUB

Q1 4 2 3 SUB P16HC 1

RCDC 1 4 75

RCAC 1 5 75

CRC 5 4 100N

CS 1 0 0.93PF

.MODEL P16HC PNP (IS=16FA BF=100 VA=60 IKF=40MA BR=0.1
+RE=0.3 RB=25 RBM=5 IRB=68MA RC=0 CJE=9.6PF VJE=0.6 MJE=0.3
+CJC=4.383PF VJC=0.64 MJC=0.3 XCJC=0.2 CCS=0 VJS=0.75 MJS=0
+FC=0.95 TF=100P XTF=25 VTF=100 ITF=500MA TR=1US EG=1.20561 XTB=6M
+XTI=2.33 KF=0.16F)

.ENDS XP16HC

*********************************
