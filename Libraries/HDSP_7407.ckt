*
* Diode Model Produced by Altium Ltd
* Date:  3-May-2004
*
* Manufacturer: Renesas
* Component Name: HDSP-7407
*
* Parameters derived from information available in data sheet.
*
*                 common-anode
*                 |  cathode-PLUS
*                 |  |  cathode-MINUS
*                 |  |  |  common-anode
*                 |  |  |  |  cathode-DP
*                 |  |  |  |  |  cathode-c
*                 |  |  |  |  |  |  cathode-b
*                 |  |  |  |  |  |  |
.SUBCKT HDSP_7407 1  2  3  6  7  8  9

DPLUS1  1  2  dHDSP_7407
DMINUS1 1  3  dHDSP_7407
DB1     1  9  dHDSP_7407
DC1     1  8  dHDSP_7407
DDP1    1  7  dHDSP_7407

DPLUS2  6  2  dHDSP_7407
DMINUS2 6  3  dHDSP_7407
DB2     6  9  dHDSP_7407
DC2     6  8  dHDSP_7407
DDP2    6  7  dHDSP_7407

.MODEL dHDSP_7407 D
+ (
+    IS = 2.77296438E-23
+    N  = 1.39205436
+    RS = 25.13253104
+    BV = 45.00000000
+    IBV = 100u
+ )

.ENDS HDSP_7407
