*MMDF2P03HD  MCE  6/12/97
*Ref: Motorola TMOS Databook Q2/96
*30V 3A .17ohm Dual Power MOSFET pkg:SMD8A (A:8,2,1)(B:6,4,3)
.SUBCKT MMDF2P03HD 10 20 40 40
*     TERMINALS:  D  G  S
M1   1  2  3  3  DMOS L=1U W=1U
RD  10  1  79.8M
RS  40  3  5.25M
RG  20  2  112
CGS  2  3  333P
EGD 12  0  1  2  1
VFB 14  0  0
FFB  1  2  VFB  1
CGD 13 14  800P
R1  13  0  1
D1  12 13  DLIM
DDG 15 14  DCGD
R2  12 15  1
D2  15  0  DLIM
DSD 10  3  DSUB
LS  30 40  7.5N
.MODEL DMOS PMOS (LEVEL=3 VMAX=62.5K THETA=80M ETA=2M VTO=-1.5 KP=22.4)
.MODEL DCGD D (CJO=800P VJ=0.6 M=0.68)
.MODEL DSUB D (IS=12.5N N=1.5 RS=0.357 BV=30 CJO=529P VJ=0.8 M=0.42 TT=42.3N)
.MODEL DLIM D (IS=100U)
.ENDS
* Origin: Mcemos.lib
