*  HA-5147
*  COPYRIGHT (C) 1991 HARRIS CORPORATION
*  ALL RIGHTS RESERVED
*
*  HA-5147 MacroModel
*  Rev: 02-04-92  DW Riemer
*
* Connections:
*               Non-Inverting Input
*               | Inverting Input
*               | | Positive Power Supply
*               | | | Negative Power Supply
*               | | | | Output
*               | | | | |
.SUBCKT HA5147  1 2 4 5 3
.MODEL DP D  IS=1E-14  N=6.3393E-01
.MODEL DN D  IS=9.0E-15    N=6.3393E-01
.MODEL DV D  IS=1.142E-14  N=.2
.MODEL D1 D  IS=1E-9  N=1
.MODEL D2 D  IS=1E-9  N=1.0
.MODEL DX D  IS=1E-20  N=30.0
*
*                     Input Stage
*  Value of source VN models Vio and may be adjusted as desired.
*
VP 1 6 0
VN 2 7 1.0E-05
I1 8 0 1.33E-08
FA 2 0 VN 1.6984E+00
DP 6 8 DP
DN 7 8 DN
C1 8 0 3.8E-17     IC=-2.1921E-01
FP 9 0 VP  5.7895E+04
FN 0 9 VN  6.4327E+04
GC 0 9 8 0 2.4744E-08
GPP 9 0 4 0 4.4246E-08
GPN 9 0 5 0 4.4246E-08
IRX 0 9 5.4243E-09
RT 9 0 1.0
*
*                 Poles and Zeros
EP1 10 0 9 0 1.0
RP1 10 11 2.388E+02
RZ1 11 12 1.592E+02
CP1 12 0 1E-10
EP2 13 0 11 0 1.0
RP2 13 14 1.592E+01
CP2 14 0 1E-10
EP3 15 0 14 0 1.0
RP3 15 16 1.1371E+01
CP3 16 0 1E-10
EP4 17 0 16 0 1.0
RP4 17 18 1.0613E+01
CP4 18 0 1E-10
EP5 19 0 18 0 1.0
RP5 19 20 +9.95
CP5 20 0 1E-10
*
*                 Output Stage
G2 0 21 20 0 1.0
R2 21 0 6.5577E+02
CC 21 22 2.2E-11
GOL 22 0 21 0 1.8093E+03
RD 22 0 5.0809E+01
DH 22 23 DV
DL 24 22 DV
*ECC 23 0 POLY 1  4 0 -2.7  1.0
BECC 23 0 V=-2.7+1.0*v(4,0)
*EEE 24 0 POLY 1  5 0 +2.7  1.0
BEEE 24 0 V=2.7+1.0*v(5,0)
IH 4 0 3.5E-03
IL 0 5 3.5E-03
GPS 25 0 22 3 8.5427E-02
DPH 4 25 DX
DPL 25 5 DX
D1 22 26 D1
D2 26 22 D2
*EX1 26 0 POLY 2  22 0 3 0 0.0   -7.2711E-01   +1.7231
BEX1 26 0 V=-7.2711E-01*v(22,0)+1.7231*v(3,0)
RO 22 3 1.17059E+01
.ENDS HA5147
