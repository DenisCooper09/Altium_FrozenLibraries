*//////////////////////////////////////////////////////////////////////
* (C) National Semiconductor, Corporation.
* Models developed and under copyright by:
* National Semiconductor, Corporation.
*/////////////////////////////////////////////////////////////////////
* Legal Notice:
* The model may be copied, and distributed without any modifications;
* however, reselling or licensing the material is illegal.
* We reserve the right to make changes to the model without prior notice.
* Pspice Models are provided "AS IS, WITH NO WARRANTY OF ANY KIND"
*////////////////////////////////////////////////////////////////////
* For more information, and our latest models,
* please visit the models section of our website at
*       http://www.national.com/models/
*////////////////////////////////////////////////////////////////////
*
* BEGIN MODEL LMV771
* PINOUT ORDER +IN -IN V+ V- OUT
* PINOUT ORDER  1   3   5  2  4
.SUBCKT LMV771 1 3 5 2 4
*
* BEGIN SIMULATOR SYNTAX VERSIONS
* BEGIN SYNTAX FOR PSPICE
R302 0 70 1E6 TC1=0.004, TC2=-0.0001
* END SYNTAX FOR PSPICE
* BEGIN SYNTAX FOR TOPSPICE
*R302 0 70 1E6 TC1=0.004 TC2=-0.0001
* END SYNTAX FOR TOPSPICE
* BEGIN SYNTAX FOR BERKELEY 3XX
*R302 0 70 1E6 RM1
*.MODEL RM1 R TC1=0.004 TC2=-0.0001
* END SYNTAX FOR BERKELEY 3XX
* BEGIN SYNTAX FOR HSPICE
*R302 0 70 1E6 TC1=0.004 TC2=-0.0001
* END SYNTAX FOR HSPICE
* END SIMULATOR SYNTAX VERSIONS
*
Q23 6 7 8 QLN
R227 9 10 1
R228 11 10 1
R229 7 12 1E3
R230 13 14 1E3
R231 15 5 3.7
R232 2 16 3.7
R234 17 18 250
R235 19 20 3.7
R236 8 21 3.7
D31 22 5 DD
D32 2 22 DD
D33 23 0 DIN
D34 24 0 DIN
I32 0 23 0.1E-3
I33 0 24 0.1E-3
E73 8 0 2 0 1
E74 20 0 5 0 1
D35 25 0 DVN
D36 26 0 DVN
I34 0 25 0.1E-3
I35 0 26 0.1E-3
E75 27 3 25 26 5.7E-3
G25 28 3 23 24 5E-7
R237 2 5 46E3
E76 29 0 20 0 1
E77 30 0 8 0 1
E78 31 0 32 0 1
R239 29 33 1E4
R240 30 34 1E5
R241 31 35 1E5
R242 0 33 1
R243 0 34 10
R244 0 35 10
E79 36 1 35 0 0.14
R245 37 32 1E3
R246 32 38 1E3
C50 29 33 20E-12
C51 30 34 20E-12
C52 31 35 10E-9
E80 39 36 34 0 0.3
E81 28 39 33 0 0.3
E82 40 8 20 8 0.5
D37 17 20 DD
D38 8 17 DD
M63 41 42 16 16 NOUT L=3U W=400U
M64 43 44 15 15 POUT L=3U W=400U
M65 45 45 19 19 POUT L=3U W=400U
M66 46 47 9 9 PIN L=3U W=525U
M67 48 49 11 11 PIN L=3U W=525U
M68 50 50 21 21 NOUT L=3U W=400U
R247 51 44 100
R248 52 42 100
G26 17 40 53 40 0.2E-3
R249 40 17 9E6
C53 18 22 35E-12
R250 8 46 2E3
R251 8 48 2E3
C54 46 48 2E-12
C55 28 0 4E-12
C56 27 0 4E-12
C57 22 0 0.5E-12
D39 42 6 DD
D40 54 44 DD
Q24 54 14 20 QLP
V99 28 55 -0.25E-3
M69 56 57 20 20 PIN L=6U W=500U
E83 38 0 28 0 1
E84 37 0 3 0 1
M70 57 57 20 20 PIN L=6U W=500U
V100 56 10 0.115
R252 22 43 9
R253 41 22 12
J9 58 28 58 JNC
J10 58 27 58 JNC
J11 27 59 27 JNC
J12 28 59 28 JNC
C58 28 60 5E-12
E85 61 40 48 46 1
R254 61 53 1E4
C59 53 40 0.7E-12
G27 62 40 17 40 -1E-3
G28 40 63 17 40 1E-3
G29 40 64 50 8 1E-3
G30 65 40 20 45 1E-3
D41 65 62 DD
D42 63 64 DD
R255 62 65 100E6
R256 64 63 100E6
R257 65 20 1E3
R258 8 64 1E3
E86 20 51 20 65 1
E87 52 8 64 8 1
R259 63 40 1E6
R260 64 40 1E6
R261 40 65 1E6
R262 40 62 1E6
R263 39 28 1E9
R264 36 39 1E9
R265 1 36 1E9
R266 3 27 1E9
R267 40 53 1E9
R268 51 20 1E9
R269 8 52 1E9
R270 32 0 1E9
I37 5 2 60E-6
L4 22 4 4E-9
R280 22 4 400
V107 20 58 0
V108 59 8 0.125
R284 45 20 1E6
R285 8 50 1E6
R286 16 42 1E6
R287 15 44 1E6
R289 60 27 100
R291 49 27 530
R292 47 55 530
E98 20 13 5 15 3
E99 12 8 16 2 3
G38 27 0 66 0 10E-15
I49 27 0 10E-15
I50 0 67 1E-3
D45 67 0 DD
V115 67 68 100.7
R301 0 68 1E6
E102 69 0 68 0 -1E-4
V116 71 66 16.6
G39 28 0 66 0 10E-15
I51 28 0 10E-15
E103 71 0 70 0 6E-3
G40 0 70 69 0 1
R303 0 69 1E6
R309 0 66 1E9
I57 45 50 420E-6
I58 57 8 126E-6
.MODEL DVN D KF=20E-12 IS=1E-16
.MODEL DD D
.MODEL DIN D
.MODEL QLN NPN
.MODEL QLP PNP
.MODEL JNC NJF
.MODEL POUT PMOS KP=200U VTO=-0.7
.MODEL NOUT NMOS KP=200U VTO=0.7
.MODEL PIN PMOS KP=200U VTO=-0.7
.MODEL NIN NMOS KP=200U VTO=0.7
.ENDS
* END MODEL LMV771
