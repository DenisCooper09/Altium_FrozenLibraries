*MMBT6427LT1 MCE 6/19/97
*Ref: Motorola Small-Signal Device Databook, Q4/94
*Si 225mW 40V 500mA pkg:SOT-23 3,1,2
.SUBCKT MMBT6427LT1 1 2 3
*    TERMINALS:  C B E
Q1 1 2 4 QPWR .1
Q2 1 4 3 QPWR
.MODEL QPWR NPN (IS=600F NF=1 BF=251 VAF=114 IKF=0.4 ISE=19.5P NE=2
+ BR=4 NR=1 VAR=48 IKR=0.6 RE=0.8 RB=3.2 RC=0.32 CJE=189P XTB=1.5
+ VJE=0.74 MJE=0.45 CJC=12.2P VJC=1.1 MJC=0.24 TF=69.6N TR=3.01U)
.ENDS
* Origin: Mcebjt.lib
