*//////////////////////////////////////////////////////////////
* LTC1250  Very Low Noise Zero-Drift Bridge Amplifier        //
*//////////////////////////////////////////////////////////////
* jjt 7/1/2002: converted temp. coeff. to Spice3 syntax.
*
* connections:     non-inverting input
*                  |   inverting input
*                  |   |   positive power supply
*                  |   |   |   negative power supply
*                  |   |   |   |   output
*                  |   |   |   |   |
*                  |   |   |   |   |
.SUBCKT LTC1250    1   2   3   4   5
*
CIN 1 2 5.5000e-011
GRIN 1 2 1 2 1.0000e-011
M1 11 2 10 10 M1 L=100U W=100U
M2 12 111 10 10 M2 L=100U W=100U

*RD1 3 11 3.5651e+002 TC=-2.0210e-008
RD1 3 11 3.5651e+002 RD1MOD
.MODEL RD1MOD R (TC1=-2.0210e-008)

*RD2 3 12 3.5651e+002 TC=2.0210e-008
RD2 3 12 3.5651e+002 RD2MOD
.MODEL RD2MOD R (TC1=2.0210e-008)

DI1 111 3 DI1
DI2 2 3 DI2
C1 11 12 2.7901e-011
IEE 10 4 DC 5.6099e-003
GA 60 99 11 12 2.8049e-003
IR1 0 101 DC 1
IR2 0 102 DC 1
DR1 101 0 DRI
DR2 102 0 DRI
GRI1 99 1 101 102 7.8148e-005
IR3 0 103 DC 1
IR4 0 104 DC 1
DR3 103 0 DRI
DR4 104 0 DRI
GRI2 99 2 103 104 7.8148e-005
RRu 605 0 1.0370e-001
VRu 605 0 DC 0
FCur 606 0 VRu 1.0
RCur1 606 0 1.0
CCur 606 607 0.45E-3
RCur2 607 0 0.2
GCur 99 60 606 0 1.0
GCM1 99 20 POLY(2) 1 99 2 99 0 5.0000e-004 5.0000e-004
RCM1 21 99 1.000000e+003
RCM2 20 99 1.0000e+006
LCM 20 21 7.9577e+000
ECM 111 1 20 99 3.1623e-007
RP1 601 99 2.5000e+003
CP1 60 601 3.1831e-011
RP11 60 99 1.0000e+004
GP1 99 6 60 99 1.0000e-004
R2 6 99 3.3500e+006
DRT 222 6 DX
RRT 222 99 1.8E6
C2 6 7 2.9605e-010
GB 7 99 6 99 7.0258e+001
R01 7 99 1.3436e+002
R02 7 50 1.0000e-001
R03 50 5 6.5543e+001
R04 5 99 1.0000e+012
VC 53 50 DC 1.1677e+000
VE 54 50 DC -1.1677e+000
DC1 53 55 DX
DC2 55 56 DX
DE1 57 54 DX
DE2 58 57 DX
GVC1 3 56 3 56 1.0E-4
GVE1 4 58 4 58 1.0E-4
GVC2 3 55 3 55 1.0E-5
GVE2 4 57 4 57 1.0E-5
GVLP 50 99  56 3 1.0000e+001
GVLN 50 99  58 4 1.0000e+001
ECLP 91 0 7 50 4.2929e+002
ECLN 92 0 7 50 2.9514e+002
DCLP 91 90 DX
DCLN 90 92 DX
VLIM 90 0 DC 0
FB 7 99 VLIM 2.6124e+004
EGND 99 0 POLY(2) 3 0 4 0 0 0.5 0.5
DSUB 4 3 DX
IP 3 4 DC -2.6099e-003
GV 31 0 7 50 1.0000e+001
DP1 3 31 DX
DP2 33 4 DX
RGV 32 33 10.0
EGV 31 32 POLY(1) 3 4 -0.85 1.0
.MODEL DX D IS=8.0000e-016 RS=0 XTI=0
.MODEL M1 NMOS LEVEL=3 KP=1.7826e-002 VTO=1.000003e+000 KF=0.0
.MODEL M2 NMOS LEVEL=3 KP=1.7826e-002 VTO=9.999973e-001 KF=0.0
.MODEL DI1  D IS=5.2500e-011 EG=-6.1495e-001 XTI=3.0000e+000
.MODEL DI2  D IS=1.7500e-011 EG=-5.5034e-001 XTI=3.0000e+000
.MODEL DRI D IS=8.0000e-016 KF=0.0000e+000 RS=0 XTI=0
*
.ENDS LTC1250
*
