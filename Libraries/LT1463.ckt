* jjt 8/1/2002: converted temp. coeff. to Spice3 syntax.
*////////////////////////////////////////////////////////////////////////////
* LT1463  Quad Micropower, 260µW C-Load Picoampere Bias Current JFET-Input //
*          Operational Amplifier                                           //
*////////////////////////////////////////////////////////////////////////////
*
* connections:     non-inverting input
*                  |   inverting input
*                  |   |   positive power supply
*                  |   |   |   negative power supply
*                  |   |   |   |   output
*                  |   |   |   |   |
*                  |   |   |   |   |
.SUBCKT LT1463     3   2   7   4   6
X_LT1463 3 2 7 4 6 LT1462
.ENDS LT1463
*
*
.SUBCKT LT1462     1 2 3 4 5
GRP1 1 111 1 111 1.0000e-002
GRP2 2 112 2 112 1.0000e-002
DIP1 114 111 DX
DIP2 115 112 DX
DIP3 116 114 DX
DIP4 116 115 DX
VCM 116 4 DC 2.6250e+000
RCMP 114 117 1.0000e+004
ECMP 117 4 111 4 1.0
RCMN 115 118 1.0000e+004
ECMN 118 4 112 4 1.0
CIN 111 112 1.7568e-012
GRIN 111 112 111 112 1.0000e-012
M1 11 112 10 10 M1 L=100U W=100U
M2 12 113 10 10 M2 L=100U W=100U

*RD1 4 11 1.6608e+003 TC=6.1884e-005
RD1 4 11 1.6608e+003 RD1MOD
.MODEL RD1MOD R (TC1=6.1884e-005)

*RD2 4 12 1.6608e+003 TC=-6.1884e-005
RD2 4 12 1.6608e+003 RD2MOD
.MODEL RD2MOD R (TC1=-6.1884e-005)

DI1 113 3 DI1
DI2 112 3 DI2
C1 11 12 7.9857e-011
IEE 3 10 DC 1.2042e-003
GSR 3 10 11 12 6.1953e-005
GA 60 99 11 12 6.0210e-004
IR1 0 101 DC 1
IR2 0 102 DC 1
DR1 101 0 DRI
DR2 102 0 DRI
GRI1 99 1 101 102 5.1921e-006
IR3 0 103 DC 1
IR4 0 104 DC 1
DR3 103 0 DRI
DR4 104 0 DRI
GRI2 99 2 103 104 5.1921e-006
RRu 605 0 2.8682e-002
VRu 605 0 DC 0
FRu 99 60 VRu 1
GCM1 99 20 POLY(2) 111 99 112 99 0 5.0000e-004 5.0000e-004
RCM1 21 99 1.000000e+003
RCM2 20 99 1.0000e+006
LCM 20 21 5.3052e-002
ECM 113 111 20 99 3.5481e-005
RP1 601 99 2.0000e+004
CP1 60 601 2.6526e-011
RP11 60 99 1.0000e+004
GP1 99 61 60 99 1.0000e-004
RP2 611 99 -2.0000e+004
LP2 61 611 -1.0610e-002
RP22 61 99 6.6667e+003
GP2 99 6 61 99 1.0000e-004
R2 6 99 1.0000e+003
C2 6 7 8.3497e-009
GB 7 99 6 99 3.2963e+002
R01 7 99 1.8071e+002
R02 7 50 1.0000e-001
R03 50 5 8.9194e+001
R04 5 99 1.0000e+012
VC 53 50 DC 2.1000e+000
VE 54 50 DC -2.1000e+000
DC1 53 55 DX
DC2 55 56 DX
DE1 57 54 DX
DE2 58 57 DX
GVC1 3 56 3 56 1.0E-4
GVE1 4 58 4 58 1.0E-4
GVC2 3 55 3 55 1.0E-5
GVE2 4 57 4 57 1.0E-5
GVLP 99 60 56 3 1.0000e+000
GVLN 99 60 58 4 1.0000e+000
ECLP 91 0 7 50 5.8824e+002
ECLN 92 0 7 50 5.8824e+002
DCLP 91 90 DX
DCLN 90 92 DX
VLIM 90 0 DC 0
FB 7 99 VLIM 7.8535e+000
EGND 99 0 POLY(2) 3 0 4 0 0 0.5 0.5
DSUB 4 3 DX
IP 3 4 DC -1.1762e-003
GV 31 0 7 50 1.0000e+001
DP1 3 31 DX
DP2 33 4 DX
RGV 32 33 10.0
EGV 31 32 POLY(1) 3 4 -0.85 1.0
.MODEL DX D IS=8.0000e-016 RS=0 XTI=0
.MODEL M1 PMOS LEVEL=3 KP=8.3042e-002 VTO=-9.996929e-001 KF=8.2812e-027
.MODEL M2 PMOS LEVEL=3 KP=8.3042e-002 VTO=-1.000307e+000 KF=8.2812e-027
.MODEL DI1  D IS=1.3625e-012 EG=7.6760e-001 XTI=3.0000e+000
.MODEL DI2  D IS=7.4826e-013 EG=8.2192e-001 XTI=3.0000e+000
.MODEL DRI D IS=8.0000e-016 KF=7.9383e-025 RS=0 XTI=0
.ENDS LT1462
*
