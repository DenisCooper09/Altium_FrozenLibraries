*///////////////////////////////////////////////////////////////////////////////////
* LTC1152 Rail-to-Rail Input Rail-to-Rail Output Zero-Drift Operational Amplifier //
*///////////////////////////////////////////////////////////////////////////////////
*
* jjt 7/1/2002: converted temp. coeff. to Spice3 syntax.
* jjt 30/5/2000: added model connection header based on 3,2,7,4,6 convention.
*   Model connections:
*
*                  +In
*                  |   -In
*                  |   |   V+
*                  |   |   |   V-
*                  |   |   |   |   Out
*                  |   |   |   |   |   COMP
*                  |   |   |   |   |   |   SHD
*                  |   |   |   |   |   |   |   CCP
*                  |   |   |   |   |   |   |   |
.SUBCKT LTC1152    1   2   3   4   5   6   8   9
*
GSW1 2 119 POLY(2) 803 99 2 119 0 0 1e-9 0 0 0 0 0 0 0 0 0 0 0 0 0 0 0 0
+  0 0 0 0 0 0 0 0 0 0 0 0 0 0 0 0 0 0 0 0 0
+  0 0 0 0 0 0 2.56e-6
RGSW1 2 119 1.0000e+009
CIN 1 119 1.3732e-011
GRIN 1 119 1 119 1.0000e-011
M1 11 119 10 10 M1 L=100U W=100U
M2 12 111 10 10 M2 L=100U W=100U

*RD1 9 11 1.7043e+005 TC=-9.3925e-008
RD1 9 11 1.7043e+005 RD1MOD
.MODEL RD1MOD R (TC1=-9.3925e-008)

*RD2 9 12 1.7043e+005 TC=9.3925e-008
RD2 9 12 1.7043e+005 RD2MOD
.MODEL RD2MOD R (TC1=9.3925e-008)

DI1 111 9 DI1
DI2 119 9 DI2
C1 11 12 3.8911e-013
IEE 10 4 DC 1.1735e-005
GSHDN 10 4 806 99 2.3708e-006
GA 60 99 11 12 5.8677e-006
DCP 3 9 DX
RCP 3 9 16.6E3
CCP 3 9 1.0E-10
GCP 3 9 POLY(1) 806 99 1.5E-4  0.33E-4
IR1 0 101 DC 1
IR2 0 102 DC 1
DR1 101 0 DRI
DR2 102 0 DRI
GRI1 99 1 101 102 2.8980e-005
IR3 0 103 DC 1
IR4 0 104 DC 1
DR3 103 0 DRI
DR4 104 0 DRI
GRI2 99 2 103 104 2.8980e-005
RRu 605 0 11.2e+001
VRu 605 0 DC 0
FCur 606 0 VRu 1.0
RCur1 606 0 1.0E
CCur 606 0 0.16E-6
GCur 99 60 606 0 1.0E-3
GCM1 99 20 POLY(2) 1 99 119 99 0 5.0000e-004 5.0000e-004
RCM1 21 99 1.000000e+003
RCM2 20 99 1.0000e+006
LCM 20 21 3.1831e+000
ECM 111 1 20 99 3.1623e-007
RR1 6 60 1.0000e-003
R2 6 99 1.0000e+003
C2 6 7 2.0900e-011
GB 7 99 6 99 2.1757e+005
R01 7 99 1.4000e+002
R02 7 50 1.0000e-001
R03 50 51 1.3990e+002
GSW2 51 5 POLY(2) 803 99 51 5 0 0 1e-9 0 0 0 0 0 0 0 0 0 0 0 0 0 0 0 0
+  0 0 0 0 0 0 0 0 0 0 0 0 0 0 0 0 0 0 0 0 0
+  0 0 0 0 0 0 2.56e-6
R04 5 99 1.0000e+012
VC 53 50 DC 9.5832e-001
VE 54 50 DC -9.6137e-001
DC1 53 55 DX
DC2 55 56 DX
DE1 57 54 DX
DE2 58 57 DX
GVC1 3 56 3 56 1.0E-4
GVE1 4 58 4 58 1.0E-4
GVC2 3 55 3 55 1.0E-5
GVE2 4 57 4 57 1.0E-5
GVLP 99 60 56 3 1.0000e+000
GVLN 99 60 58 4 1.0000e+000
ECLP 91 0 7 50 7.1429e+002
ECLN 92 0 7 50 8.0000e+002
DCLP 91 90 DX
DCLN 90 92 DX
VLIM 90 0 DC 0
FB 7 99 VLIM 5.0518e+001
EGND 99 0 POLY(2) 3 0 4 0 0 0.5 0.5
DSUB 4 3 DX
GIP 3 4 POLY(1) 99 803 3.9330e-008 4.3745e-004
GV 31 0 7 50 1.0000e+001
DP1 3 31 DX
DP2 33 4 DX
RGV 32 33 10.0
EGV 31 32 POLY(1) 3 4 -0.85 1.0
RDIS1 8 3 1.0000e+012
DDIS1 801 8 DX
RDIS2 801 802 3.5708e+006
VDIS1 800 802 DC 0
EDIS 3 800 3 99 0.35
FDIS 99 803 POLY(1) VDIS1 -30E-3 5.0000e+004
RDIS3 803 99 1.0000e+003
DDIS2 803 804 DON
VDIS2 804 99 DC -8.0100e-001
DDIS3 805 803 DOFF
VDIS3 805 99 DC -4.1950e+000
CDIS1 803 99 5.0000e-011
EDIS2 806 99 POLY(1) 803 99 -5.0 -1.0
RDIS4 806 99 1.0000e+006
.MODEL DX D IS=8.0000e-016 RS=0 XTI=0
.MODEL M1 NMOS LEVEL=3 KP=9.1841e-004 VTO=1.000001e+000 KF=0.0
.MODEL M2 NMOS LEVEL=3 KP=9.1841e-004 VTO=9.999992e-001 KF=0.0
.MODEL DI1  D IS=1.9237e-011 EG=1.7586e-001 XTI=3.0000e+000
.MODEL DI2  D IS=6.4482e-012 EG=2.0832e-001 XTI=3.0000e+000
.MODEL DRI D IS=8.0000e-016 KF=0.0 RS=0 XTI=0
.MODEL DON D IS=8.0000e-016 TT=9.9886e-006 CJO=0.3E-12 RS=0 XTI=0
.MODEL DOFF  D IS=8.0000e-016 TT=3.8058e-006 CJO=0.3E-12 RS=0 XTI=0
*
.ENDS LTC1152
*
