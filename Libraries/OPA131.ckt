* OPA131 operational amplifier "macromodel" subcircuit

* created using Parts release 5.4 on 01/14/95 at 21:25

* REV. A    SB

*

*  ------------------------------------------------------------------------

* |  NOTICE: THE INFORMATION PROVIDED HEREIN IS BELIEVED TO BE RELIABLE;   |

* |  HOWEVER; BURR-BROWN ASSUMES NO RESPONSIBILITY FOR INACCURACIES OR     |

* |  OMISSIONS.  BURR-BROWN ASSUMES NO RESPONSIBILITY FOR THE USE OF THIS  |

* |  INFORMATION, AND ALL USE OF SUCH INFORMATION SHALL BE ENTIRELY AT     |

* |  THE USER'S OWN RISK.  NO PATENT RIGHTS OR LICENSES TO ANY OF THE      |

* |  CIRCUITS DESCRIBED HEREIN ARE IMPLIED OR GRANTED TO ANY THIRD PARTY.  |

* |  BURR-BROWN DOES NOT AUTHORIZE OR WARRANT ANY BURR-BROWN PRODUCT FOR   |

* |  USE IN LIFE-SUPPORT DEVICES AND/OR SYSTEMS.                           |

*  ------------------------------------------------------------------------

*

* connections:   non-inverting input

*                | inverting input

*                | | positive power supply

*                | | | negative power supply

*                | | | | output

*                | | | | |

.subckt OPA131   1 2 3 4 5

*

  c1   11 12 4.197E-12

  c2    6  7 18.00E-12

  css  10 99 7.200E-12

  dc    5 53 dx

  de   54  5 dx

  dlp  90 91 dx

  dln  92 90 dx

  dp    4  3 dx

  egnd 99  0 poly(2) (3,0) (4,0) 0 .5 .5

  fb    7 99 poly(5) vb vc ve vlp vln 0 127.3E6 -130E6 130E6 130E6 -130E6

  ga    6  0 11 12 452.4E-6

  gcm   0  6 10 99 45.24E-9

  iss   3 10 dc 252.0E-6

  hlim 90  0 vlim 1K

  j1   11  2 10 jx

  j2   12  1 10 jx

  r2    6  9 100.0E3

  rd1   4 11 2.210E3

  rd2   4 12 2.210E3

  ro1   8  5 50

  ro2   7 99 25

  rp    3  4 20.00E3

  rss  10 99 793.7E3

  vb    9  0 dc 0

  vc    3 53 dc 2.500

  ve   54  4 dc 2.500

  vlim  7  8 dc 0

  vlp  91  0 dc 20

  vln   0 92 dc 20

.model dx D(Is=800.0E-18)

.model jx PJF(Is=2.500E-12 Beta=812.1E-6 Vto=-1)

.ends  OPA131


