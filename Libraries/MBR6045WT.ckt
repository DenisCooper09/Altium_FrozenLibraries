* .: 1 = Anode; .: 2 = Cathode; .: 3 = Anode
.SUBCKT mbr6045wt 1 2 3
D1 1 2 mbr6045wt
D2 3 2 mbr6045wt

.MODEL mbr6045wt d
+(
+IS=0.000193712 RS=0.0036073 N=1.64274 EG=1.3
+XTI=0.5 BV=45 IBV=0.0001 CJO=4.10772e-09
+VJ=0.640163 M=0.517178 FC=0.5 TT=1e-09
+KF=0 AF=1
+)

.ENDS mbr6045wt
