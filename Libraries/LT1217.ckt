*//////////////////////////////////////////////////////////////
* LT1217       Low Power 10MHz Current Feedback Amplifier    //
*//////////////////////////////////////////////////////////////
*
* connections:     non-inverting input
*                  |   inverting input
*                  |   |   positive power supply
*                  |   |   |   negative power supply
*                  |   |   |   |   output
*                  |   |   |   |   |
*                  |   |   |   |   |
.SUBCKT LT1217     3   2   7   4   6
*
Q2A 4 3 10 QP 0.5
Q3A 11 10 200 QN
Q4A 11 11 7 QP
Q5A 9 11 7 QP
Q6A 12 11 7 QP
Q7A 4 9 12 QP
Q8A 7 12 13 QN 10
RSCA 13 6 8
IBA 7 10 DC 40U
*
Q2B 7 3 110 QN 0.5
Q3B 111 110 200 QP
Q4B 111 111 4 QN
*
Q5B 9 111 4 QN
Q6B 112 111 4 QN
Q7B 7 9 112 QN
Q8B 4 112 113 QP 10
RSCB 6 113  8
IBB 110 4 DC 40U
*
RC 2 200 16
R9 9 0 5MEG
D1 9 6 DC
D2 6 9 DC
*
.MODEL DC D
*
.MODEL QN NPN (IS=160E-18 BF=170 ISC=40E-18 NC=1 RB=250 RE=8 RC=100
+CJE=0.37P VJE=0.65 MJE=0.33 FC=0.7 CJC=2.1P VJC=0.62 MJC=0.44
+TF=500P
*
.MODEL QP PNP (IS=165E-18 BF=150 ISC=113E-18 NC=1 RB=250 RE=8 RC=100
+CJE=0.34P VJE=0.75 MJE=0.40 FC=0.7 CJC=2.1P VJC=0.62 MJC=0.44
+TF=500P
*
.ENDS LT1217
