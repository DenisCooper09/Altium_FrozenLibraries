*
*ZETEX  ZVN4206A Mosfet Spice Subcircuit   Last revision 30/01/02
*
*NOTE: If required increase ABSTOL to resolve convergence problems.
*
* BC 5/1/2004: converted from pspice to spice
*
.SUBCKT ZVN4206A 3 4 5
*------connections-------D-G-S
M1 6 2 8 8 MOSMOD
M2 6 2 8 8 MOSMODS
RG 4 2 30
RD 3 6 0.05
RS 8 5 0.5
RL 3 5 6E6
C1 2 8 80E-12
C2 2 3 25E-12
C3 15 14 75E-12
C4 16 8 40E-12
D1 5 3 DMOD
S1 2 15 14 13 SMOD1
S2 13 15 13 14 SMOD1
S3 16 13 13 8 SMOD2
S4 16 2 8 13 SMOD2
Egs2 13 8 2 8 1
Eds1 14 8 3 8 1
.MODEL MOSMOD NMOS VTO=2.4 IS=1E-15 KP=0.84 CBD=195E-12 PB=1
.MODEL MOSMODS NMOS VTO=1.8 IS=1E-15 KP=0.084 PB=1
.MODEL DMOD D IS=6E-13 RS=.13 N=1.01

* .MODEL SMOD1 VSWITCH RON=.1 ROFF=1E5  VON=1.5 VOFF=4.5
.MODEL SMOD1 SW  (RON=.1 ROFF=1E5 VT=3 VH=-1.5 )

* .MODEL SMOD2 VSWITCH RON=.1 ROFF=1E5  VON=-5 VOFF=-6
.MODEL SMOD2 SW  (RON=.1 ROFF=1E5  VT=-5.5 VH=0.5)
.ENDS  ZVN4206A
*
*$
*                          (C)  2002 ZETEX PLC
*
*   The copyright in this model  and  the design embodied belong to
*   Zetex PLC ("Zetex"). It is supplied free of charge by Zetex for
*   the purpose  of research  and design  and may be used or copied
*   intact (including this notice) for that purpose only. All other
*   rights  are  reserved.  The model  is believed  accurate but no
*   condition or warranty as to its  merchantability or fitness for
*   purpose  is  given  and  no liability  in respect of any use is
*   accepted by Zetex PLC, its distributors or agents.
*
*
*   Zetex PLC, Fields New Road, Chadderton, Oldham  OL9 8NP
