*RF1S30P06SM MCE  5/27/98
* jjt 4/4/2002: changed sign of VTO to match Jul 1999 datasheet
*60V 30A .065ohm Power MOSFET pkg:TO263AB 4,1,3
.SUBCKT RF1S30P06SM 10 20 40 40
*     TERMINALS:  D  G  S
M1   1  2  3  3  DMOS L=1U W=1U
RD  10  1  29.9M
RS  40  3  2.62M
RG  20  2  5
CGS  2  3  3.03N
EGD 12  0  1  2  1
VFB 14  0  0
FFB  1  2  VFB  1
CGD 13 14  2.25N
R1  13  0  1
D1  12 13  DLIM
DDG 15 14  DCGD
R2  12 15  1
D2  15  0  DLIM
DSD 10  3  DSUB
LS  30 40  7.5N
.MODEL DMOS PMOS (LEVEL=3 VMAX=125K THETA=60M ETA=2M VTO=-3 KP=13.8)
.MODEL DCGD D (CJO=2.25N VJ=0.6 M=0.68)
.MODEL DSUB D (IS=125N N=1.5 RS=25M BV=60 CJO=2.69N VJ=0.8 M=0.42 TT=150N)
.MODEL DLIM D (IS=100U)
.ENDS
