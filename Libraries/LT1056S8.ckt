*////////////////////////////////////////////////////////////////////
* LT1056S8  Precision, High-Speed, JFET-Input Operational Amplifier //
*////////////////////////////////////////////////////////////////////
*
* connections:     non-inverting input
*                  |   inverting input
*                  |   |   positive power supply
*                  |   |   |   negative power supply
*                  |   |   |   |   output
*                  |   |   |   |   |
*                  |   |   |   |   |
.SUBCKT LT1056S8   3   2   7   4   6
* INPUT
VCM2 40 4 2.0000E+00
RD1 40 80 9.6458E+02
RD2 40 90 9.6458E+02
J1 80 102 12 JM1
J2 90 103 12 JM2
CIN 2 3 4.0000E-12
RG1 2 102 2.0000E+00
RG2 3 103 2.0000E+00
** CM CLAMP
* DCM1 107 103 DM4
* DCM2 105 107 DM4
* VCMC 105 4 4.0E+00
* ECMP 106 4 103 4 1
* RCMP 107 106 1E+04
* DCM3 109 102 DM4
* DCM4 105 109 DM4
* ECMN 108 4 102 4 1
* RCMN 109 108 1E+04
** END CM CLAMP
C1 80 90 1.5000E-11
ISS 7 12 5.6000E-04
GOSIT 7 12 90 80 2.8000E-04
* INTERMEDIATE
GCM 0 8 12 0 1.3052E-08
GA 8 0 80 90 1.0367E-03
R2 8 0 1.0000E+05
C2 1 8 3.0000E-11
GB 1 0 8 0 7.8368E+01
RO2 1 0 4.9000E+01
* OUTPUT
RSO 1 6 1.0000E+00
ECL 18 0 1 6 1.7377E+01
GCL 0 8 20 0 1.0000E+00
RCL 20 0 1.0000E+03
D1 18 20 DM1
D2 20 18 DM1
*
D3A 131 70 DM3
D3B 13 131 DM3
GPL 0 8 70 7 1.0000E+00
VC 13 6 2.9595E+00
RPLA 7 70 1.0000E+04
RPLB 7 131 1.0000E+05
D4A 60 141 DM3
D4B 141 14 DM3
GNL 0 8 60 4 1.0000E+00
VE 6 14 2.9595E+00
RNLA 60 4 1.0000E+04
RNLB 141 4 1.0000E+05
*
IP 7 4 4.4400E-03
DSUB 4 7 DM2
* MODELS
.MODEL JM1 PJF (IS=3.2500E-11 BETA=9.5964E-04 VTO=-1.000000E+00)
.MODEL JM2 PJF (IS=2.7500E-11 BETA=9.5964E-04 VTO=-9.995000E-01)
.MODEL DM1 D (IS=1.0000E-15)
.MODEL DM2 D (IS=8.0000E-16 BV=4.8000E+01)
.MODEL DM3 D (IS=1.0000E-16)
.MODEL DM4 D (IS=1.0000E-09)
.ENDS LT1056S8
