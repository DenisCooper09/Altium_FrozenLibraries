*ZETEX  ZVN4210A  Spice Mosfet Subcircuit   Last revision 3/97
*
.SUBCKT ZVN4210A 3 4 5
* Nodes          D G S
M1 3 2 5 5 MOD1
RG 4 2 401.5
RL 3 5 1E7
D1 5 3 DIODE1
.MODEL MOD1 NMOS VTO=1.922 RS=0.858 RD=0.2025 IS=1E-15 KP=2.082
+CGSO=61.5P CGDO=3.5P CBD=108P PB=1 LAMBDA=0
.MODEL DIODE1 D IS=1.10461E-12 N=1.0114 RS=0.166
.ENDS ZVN4210A
*
*                          (C)  1991 ZETEX PLC
*
*   The copyright in this model  and  the design embodied belong to
*   Zetex PLC ("Zetex"). It is supplied free of charge by Zetex for
*   the purpose  of research  and design  and may be used or copied
*   intact (including this notice) for that purpose only. All other
*   rights  are  reserved.  The model  is believed  accurate but no
*   condition or warranty as to its  merchantability or fitness for
*   purpose  is  given  and  no liability  in respect of any use is
*   accepted by Zetex PLC, its distributors or agent.
*
*
*   Zetex PLC, Fields New Road, Chadderton, Oldham  OL9 8NP
