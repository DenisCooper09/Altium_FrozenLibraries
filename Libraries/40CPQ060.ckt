* .: 1 = Anode; .: 2 = Cathode; .: 3 = Anode
.SUBCKT 40cpq060 1 2 3
D1 1 2 40cpq060
D2 3 2 40cpq060

.MODEL 40cpq060 d
+(
+IS=2.4532e-11 RS=0.0071 N=0.5 EG=0.6
+XTI=0.5 BV=1000 IBV=0.0001 CJO=2.49633e-09
+VJ=1.5 M=0.483473 FC=0.5 TT=1e-09
+KF=0 AF=1
+)

.ENDS 40cpq060
