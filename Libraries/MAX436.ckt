*   ////////////// MAX436 MACROMODEL //////////////////
*
*   ====>      REFER TO MAX436 DATA SHEET       <====
*
* SUBCIRCUIT CONNECTIONS +VIN -VIN -Z +Z +V -V +IOUT  RSET
*
.SUBCKT MAX436 9 29 14 34 99 50 16 51
*Pinout: +VIN -VIN -Z +Z +V -V +IOUT  RSET
***************************************
*F10 99 16 POLY(1) VSET .003 6.383 -188.9
BF10 99 16 I=.003+6.383*I(VSET)-188.9*I(VSET)*I(VSET)
*POLY SOURCE FOR SETTING QUIESCENT CURRENTS VIA RSET.
*F11 99 14 POLY(1) VSET  7.5E-4  1.596 -47.23
BF11 99 14 I=7.5E-4+1.596*I(VSET)-47.23*I(VSET)*I(VSET)
Q1 99 9 8 Q
Q2 12 8 14 QPNP
F1 8 50 VSENSE1 0.5
F2 16 50 VSENSE1 8
VSENSE1 12 50 0V
CBW1 16 50 23P
******OUTPUT CLAMPING
D1 40 99 DX
D2 50 41 DX
V1 40 16 2.26V
V2 16 41 2.26V
********************** 2nd Half of Circuit
*F30 99 16 POLY(1) VSET 0.003 6.383 -188.9
BF30 99 16 I=0.003+6.383*I(VSET)-188.9*I(VSET)*I(VSET)
*F31 99 34 POLY(1) VSET  7.5E-4  1.596 -47.23
BF31 99 34 I=7.5E-4+1.596*I(VSET)-47.23*I(VSET)*I(VSET)
Q21 99 29 28 Q
Q22 32 28 34 QPNP
F21 28 50 VSENSE21 0.5
VSENSE21 32 50 0V
***********
VSET 0 51 -3.7V
.MODEL QPNP PNP (Bf=10E5)
.MODEL QNPN NPN (Bf=10E5)
.MODEL Q   NPN (Bf=15E5)
.MODEL DX D(IS=1E-15)
.ENDS
