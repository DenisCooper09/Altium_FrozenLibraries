*
* Diode Model Produced by Altium Ltd
* Date:  3-May-2004
*
* Manufacturer: Renesas
* Component Name: HDSP-A157
*
* Parameters derived from information available in data sheet.
*
*                 common-anode
*                 |  cathode-PLUS
*                 |  |  cathode-MINUS
*                 |  |  |  common-anode
*                 |  |  |  |  cathode-DP
*                 |  |  |  |  |  cathode-c
*                 |  |  |  |  |  |  cathode-b
*                 |  |  |  |  |  |  |
.SUBCKT HDSP_A157 1  2  3  6  7  8  9

DPLUS1  1  2  dHDSP_A157
DMINUS1 1  3  dHDSP_A157
DB1     1  9  dHDSP_A157
DC1     1  8  dHDSP_A157
DDP1    1  7  dHDSP_A157

DPLUS2  6  2  dHDSP_A157
DMINUS2 6  3  dHDSP_A157
DB2     6  9  dHDSP_A157
DC2     6  8  dHDSP_A157
DDP2    6  7  dHDSP_A157

.MODEL dHDSP_A157 D
+ (
+    IS  = 2.08276754E-16
+     N  = 2.17799178
+    RS  = 0.50892350
+    BV  = 14.25
+   IBV  = 100u
+ )

.ENDS HDSP_A157
