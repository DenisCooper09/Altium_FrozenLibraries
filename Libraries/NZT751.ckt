*NZT751 MCE 5-9-97
*Ref: National Discrete Products Databook, 1996
*Si 1.2W 60V 4A 75MHz CurrentDrvr pkg:SOT-223 2,1,3
.SUBCKT NZT751   1 2 3
*    TERMINALS:  C B E
Q1 1 2 3  QPWR .67
Q2 1 4 3  QPWR .33
RBS  2 4  30.5
.MODEL QPWR PNP (IS=295F NF=1 BF=104 VAF=139 IKF=1.33 ISE=248P NE=2
+ BR=4 NR=1 VAR=20 IKR=2 RE=82.9M RB=0.331 RC=33.1M XTB=1.5
+ CJE=293P VJE=0.6 MJE=0.3 CJC=190P VJC=0.22 MJC=0.2 TF=2.12N TR=81.6N)
.ENDS
