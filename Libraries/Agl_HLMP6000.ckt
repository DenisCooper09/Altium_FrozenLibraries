* Agl_HLMP6000 LED Model
* Created by Shaun Quin 30-05-2002
* jj 22/8/2002: modified to include series resistor
*Typ LED: Vf=1.6V Vr=12V If=10mA
*LED Pinout: 1=A, 2=K
.subckt hlmp6000 1  2
D1 1 3 Agl_HLMP6000
R1 3 2 440
.MODEL Agl_HLMP6000 D (IS=214n RS=118.56 N=1.5 BV=12 IBV=100U
+ CJO=100P VJ=.75 M=.333 TT=15n)
*Temperature and Noise Effects are not Modelled
.ends hlmp6000
