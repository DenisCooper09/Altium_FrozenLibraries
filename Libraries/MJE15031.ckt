*MJE15031 MCE 2/24/97
*Si   50W 150V    8A  86MHz pkg:TO-220 2,1,3
.SUBCKT MJE15031 1 2 3
Q1 1 2 3  QPWR .67
Q2 1 4 3  QPWR .33
RBS  2 4  12.5
.MODEL QPWR PNP (IS=22P NF=1 BF=195 VAF=220 IKF=3.5 ISE=1.85N NE=2
+ BR=4 NR=1 VAR=20 IKR=5.25 RE=97.7M RB=0.391 RC=39.1M XTB=1.5
+ CJE=1.34N VJE=0.6 MJE=0.3 CJC=320P VJC=0.22 MJC=0.2 TF=1.85N TR=2.38U)
.ENDS MJE15031
* Origin: Mcebjt.lib
