* BEGIN MODEL LMP7732
*//////////////////////////////////////////////////////////////////////
*Rev.a September 2007
*//////////////////////////////////////////////////////////////////////
* (C) National Semiconductor, Corporation.
* Models developed and under copyright by:
* National Semiconductor, Corporation.
*/////////////////////////////////////////////////////////////////////
* Legal Notice:
* The model may be copied, and distributed without any modifications;
* however, reselling or licensing the material is illegal.
* We reserve the right to make changes to the model without prior notice.
* Pspice Models are provided "AS IS, WITH NO WARRANTY OF ANY KIND"
*////////////////////////////////////////////////////////////////////
* MODEL TEMP RANGE IS -40 TO +125 DEG C.
* NOTE THAT MODEL IS FUNCTIONAL OVER THIS
* RANGE BUT NOT ALL PARAMETERS TRACK
* THOSE OF THE REAL PART.
* NOTE THAT SUPPLY CURRENT IS MODELED FOR ONLY ONE AMPLIFIER
* AND IS HENCE HALF OF THE TOTAL SUPPLY CONSUMED BY THE LMP7732
*///////////////////////////////////////////////////////////////////////
* PINOUT ORDER +IN -IN V+ V- OUT
* PINOUT ORDER  3   4   5  2  1
.SUBCKT LMP7732 3 4 5 2 1
*///////////////////////////////////////////////////////////////////////
* USE V10 BELOW TO ADJUST OFFSET
V10 13 25 0.22E-6
*////////////////////////////////////////////////////////////////////////
* MODEL FEATURES INCLUDE OUTPUT SWING, OUTPUT CURRENT THRU
* THE SUPPLY RAILS, OUTPUT CURRENT LIMIT, OPEN LOOP GAIN
* AND PHASE WITH RL AND CL EFFECTS, SLEW RATE, COMMON MODE
* REJECTION WITH FREQ EFFECTS, POWER SUPPLY REJECTION WITH
* FREQ EFFECTS, INPUT VOLTAGE NOISE WITH 1/F, INPUT CURRENT
* NOISE WITH 1/F, INPUT BIAS CURRENT, INPUT COMMON MODE
* RANGE, INPUT OFFSET VOLTAGE WITH TEMPERATURE EFFECTS,
* AND QUIESCENT CURRENT VS VOLTAGE AND TEMPERATURE.
* MODEL INCLUDES TRIPLE DIFF INPUT PROTECTION DIODES.
*//////////////////////////////////////////////////////////////////
* MODEL TEMP RANGE IS -40 TO +125 DEG C.
* NOTE THAT MODEL IS FUNCTIONAL OVER THIS RANGE BUT NOT ALL PARAMETERS TRACK
* THOSE OF THE REAL PART.
*///////////////////////////////////////////////////////////////////////

Q33 6 7 8 QPC
R45 9 10 1
R46 11 10 1
R47 12 13 130
R49 14 15 2K
R50 14 16 2K
R51 17 18 130
Q35 19 19 20 QPC
Q36 21 21 19 QPC
Q37 20 20 22 QN
Q38 22 22 23 QN
D13 20 8 DD
D14 18 8 DD
D15 24 25 DD
D16 24 18 DD
V9 20 25 0
D17 26 0 DIN
D18 27 0 DIN
I14 0 26 0.1E-3
I15 0 27 0.1E-3
C13 12 0 1.5E-12
C14 4 0 1.5E-12
D19 28 0 DVN
D20 29 0 DVN
I16 0 28 0.1E-3
I17 0 29 0.1E-3
E15 17 4 28 29 0.046
G5 12 17 26 27 3.4E-4
E16 30 0 8 0 1
E17 31 0 14 0 1
E18 32 0 33 0 1
R56 30 34 1E6
R57 31 35 1E6
R58 32 36 1E6
R59 0 34 100
R60 0 35 100
R61 0 36 100
E19 37 38 36 0 5E-4
R62 39 33 1E3
R63 33 40 1E3
C15 30 34 1E-12
C16 31 35 1E-12
C17 32 36 1E-12
E20 41 37 35 0 -10.6E-3
E21 12 41 34 0 9.4E-3
C19 15 16 0.25E-12
M1 16 25 9 9 MDP L=2U W=1400U
M2 15 18 11 11 MDP L=2U W=1400U
G6 7 8 42 0 1.3E-6
R64 0 42 1E12
V52 42 0 1
I18 0 12 5E-9
I19 0 4 5E-9
V53 24 14 0.18
V54 6 10 -0.8
G12 12 17 43 0 1.45E-4
R136 0 43 10E3
R137 0 43 10E3
R138 38 37 1E9
R139 37 41 1E9
R140 41 12 1E9
E54 40 0 12 0 1
E55 39 0 17 0 1
C23 12 17 0.05E-12
Q39 44 44 21 QPC
Q40 23 23 44 QN
E57 38 3 45 0 2.81E-4
R146 38 3 1E9
R147 0 42 1E12
Q41 46 47 14 QLN
R148 47 48 1E3
R149 49 50 1E3
R150 51 5 5
R151 2 52 5
R153 53 54 30
R154 55 8 5
R155 14 56 5
D22 57 5 DD
D23 2 57 DD
E58 14 0 2 0 1
E59 8 0 5 0 1
R156 2 5 10E3
E60 58 14 8 14 0.51
D24 53 8 DD
D25 14 53 DD
M3 59 60 52 52 NL L=3U W=1000U
M4 61 62 51 51 PL L=3U W=1000U
M5 63 63 55 55 PL L=3U W=1000U
M9 64 64 56 56 NL L=3U W=1000U
R157 65 62 100
R158 66 60 100
G14 53 58 67 58 0.2E-3
R159 58 53 1.7E7
C24 54 68 20E-12
C25 57 0 0.5E-12
D26 60 46 DD
D27 69 62 DD
Q42 69 50 8 QLP
R160 57 61 10
R161 59 57 10
E61 70 58 15 16 1
R162 70 67 1E4
C26 67 58 0.1E-12
G15 71 58 53 58 -1E-3
G16 58 72 53 58 1E-3
G17 58 73 64 14 1E-3
G18 74 58 8 63 1E-3
D28 74 71 DD
D29 72 73 DD
R163 71 74 100E6
R164 73 72 100E6
R165 74 8 1E3
R166 14 73 1E3
E62 8 65 8 74 1
E63 66 14 73 14 1
R167 72 58 1E6
R168 73 58 1E6
R169 58 74 1E6
R170 58 71 1E6
G19 5 2 45 0 -3.5E-3
R171 58 67 1E9
R172 65 8 1E9
R173 14 66 1E9
G20 63 64 42 0 180E-6
I22 5 2 1.82E-3
L2 57 1 0.4E-9
R175 57 1 400
R176 63 8 1E8
R177 14 64 1E8
R178 52 60 1E8
R179 51 62 1E8
E99 8 49 5 51 3.45
E100 48 14 52 2 3.45
E124 68 0 57 0 1
R719 53 68 3E9
I30 0 75 1E-3
D46 75 0 DD
R182 0 75 10E6
V127 75 45 0.65
R779 0 45 10E6
R180 18 44 50
R181 4 17 1E9
.MODEL DD D
.MODEL QN NPN
.MODEL QPC PNP
.MODEL DVN D KF=2.5E-16
.MODEL DIN D KF=8E-17
.MODEL MDP PMOS KP=600U VTO=-0.7
.MODEL PL PMOS KP=200U VTO=-0.7
.MODEL NL NMOS KP=200U VTO=0.7
.MODEL QLN NPN
.MODEL QLP PNP
.ENDS
* END MODEL LMP7732
