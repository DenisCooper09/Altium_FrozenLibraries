* MC33282 operational amplifier
*"macromodel" subcircuit
*
* connections:
*    1 -  non-inverting input
*    2 -  inverting input
*    3 -  positive power supply
*    4 -  negative power supply
*    5 -  output
*
.subckt MC33282  1 2 3 4 5
*
  c1   11 12 4.767E-12
  c2    6  7 8.000E-12
  dc    5 53 dx
  de   54  5 dx
  dlp  90 91 dx
  dln  92 90 dx
  dp    4  3 dx
*egnd 99  0 poly(2) (3,0) (4,0) 0 .5 .5
  begnd 99  0 v=.5*v(3,0)+.5*v(4,0)
*fb    7 99 poly(5) vb vc ve vlp vln 0 14.47E6-10E6 10E6 10E6 -10E6
  bfb   7 99 i=14.47E6-10E6*i(vb)+10E6*i(vc)+10E6*i(ve)-10E6*i(vlp)
  ga    6  0 11 12 276.5E-6
  gcm   0  6 10 99 8.742E-9
  iss   3 10 dc 120.0E-6
  hlim 90  0 vlim 1K
  j1   11  2 10 jx
  j2   12  1 10 jx
  r2    6  9 100.0E3
  rd1   4 11 3.617E3
  rd2   4 12 3.617E3
  ro1   8  5 50
  ro2   7 99 50
  rp    3  4 13.95E3
  rss  10 99 1.667E6
  vb    9  0 dc 0
  vc    3 53 dc 1.300
  ve   54  4 dc 1.100
  vlim  7  8 dc 0
  vlp  91  0 dc 21
  vln   0 92 dc 21
.model dx D(Is=800.0E-18)
.model jx PJF(Is=15.00E-12 Beta=636.9E-6 Vto=-1)
.ends
*$
