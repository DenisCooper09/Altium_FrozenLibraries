*
* Diode Model Produced by Altium Ltd
* Date:  10-Mar-2004
*
* Manufacturer: Agilent
* Component Name: HDSP-G03A
*
* Parameters derived from information available in data sheet.
*
*                 anode-C-1
*                 |  anode-E-1
*                 |  |  anode-D-1
*                 |  |  |  common-cathode-1
*                 |  |  |  |  common-cathode-2
*                 |  |  |  |  |  anode-D-2
*                 |  |  |  |  |  |  anode-E-2
*                 |  |  |  |  |  |  |  anode-C-2
*                 |  |  |  |  |  |  |  |  anode-G-2
*                 |  |  |  |  |  |  |  |  |  anode-A-2
*                 |  |  |  |  |  |  |  |  |  |  anode-F-2
*                 |  |  |  |  |  |  |  |  |  |  |  anode-B-2
*                 |  |  |  |  |  |  |  |  |  |  |  |  anode-B-1
*                 |  |  |  |  |  |  |  |  |  |  |  |  |  anode-F-1
*                 |  |  |  |  |  |  |  |  |  |  |  |  |  |  anode-A-1
*                 |  |  |  |  |  |  |  |  |  |  |  |  |  |  |  anode-G-1
*                 |  |  |  |  |  |  |  |  |  |  |  |  |  |  |  |
.SUBCKT HDSP_G03A 1  2  3  4  5  6  7  8  9  10 11 12 13 14 15 16

DA1 15  4 dHDSP_G03A
DB1 13  4 dHDSP_G03A
DC1  1  4 dHDSP_G03A
DD1  3  4 dHDSP_G03A
DE1  2  4 dHDSP_G03A
DF1 14  4 dHDSP_G03A
DG1 16  4 dHDSP_G03A

DA2 10  5 dHDSP_G03A
DB2 12  5 dHDSP_G03A
DC2  8  5 dHDSP_G03A
DD2  6  5 dHDSP_G03A
DE2  7  5 dHDSP_G03A
DF2 11  5 dHDSP_G03A
DG2  9  5 dHDSP_G03A

.MODEL  dHDSP_G03A D
+ (
+    IS  = 4.92088043E-22
+     N  = 1.51994259
+    RS  = 3.79496255
+    BV  = 4.5
+   IBV  = 100u
+ )

.ENDS HDSP_G03A
