*
* Diode Model Produced by Altium Ltd
* Date:  10-Mar-2004
*
* Manufacturer: Agilent
* Component Name: HDSP-F407
*
* Parameters derived from information available in data sheet.
*
*                 common-anode
*                 |  cathode-PLUS
*                 |  |  cathode-MINUS
*                 |  |  |  common-anode
*                 |  |  |  |  cathode-DP
*                 |  |  |  |  |  cathode-c
*                 |  |  |  |  |  |  cathode-b
*                 |  |  |  |  |  |  |
.SUBCKT HDSP_F407 1  2  3  6  7  8  9

DPLUS1  1 2 dHDSP_F407
DMINUS1 1 3 dHDSP_F407
DB1     1 9 dHDSP_F407
DC1     1 8 dHDSP_F407
DDP1    1 7 dHDSP_F407

DPLUS2  6 2 dHDSP_F407
DMINUS2 6 3 dHDSP_F407
DB2     6 9 dHDSP_F407
DC2     6 8 dHDSP_F407
DDP2    6 7 dHDSP_F407

.MODEL dHDSP_F407 D
+ (
+     IS = 3.04174763E-24
+      N = 1.23122391
+     RS = 24.19303791
+     BV = 30
+    IBV = 100u
+ )

.ENDS HDSP_F407
