*
* Diode Model Produced by Altium Ltd
* Date:  5-Apr-2004
*
* Manufacturer: Agilent
* Component Name: HDSP_431G
*
* Parameters derived from information available in data sheet.
*
*                 common-anode-1
*                 |  cathode-e
*                 |  |  cathode-c
*                 |  |  |  cathode-d
*                 |  |  |  |  common-anode-2
*                 |  |  |  |  |  cathode-DP
*                 |  |  |  |  |  |  common-anode-3
*                 |  |  |  |  |  |  |  cathode-g
*                 |  |  |  |  |  |  |  |  cathode-b
*                 |  |  |  |  |  |  |  |  |  cathode-a
*                 |  |  |  |  |  |  |  |  |  |  common-anode-L
*                 |  |  |  |  |  |  |  |  |  |  |  cathode-f
*                 |  |  |  |  |  |  |  |  |  |  |  |
.SUBCKT HDSP_431G 1  2  3  4  5  6  7  8  11 12 14 15

DA1   1  12  dHDSP_431G
DB1   1  11  dHDSP_431G
DC1   1   3  dHDSP_431G
DD1   1   4  dHDSP_431G
DE1   1   2  dHDSP_431G
DF1   1  15  dHDSP_431G
DG1   1   8  dHDSP_431G
DDP1  1   6  dHDSP_431G

DL1  14  12  dHDSP_431G
DL2  14  11  dHDSP_431G
DL3  14   3  dHDSP_431G

DA2   5  12  dHDSP_431G
DB2   5  11  dHDSP_431G
DC2   5   3  dHDSP_431G
DD2   5   4  dHDSP_431G
DE2   5   2  dHDSP_431G
DF2   5  15  dHDSP_431G
DG2   5   8  dHDSP_431G
DDP2  5   6  dHDSP_431G

DA3   7  12  dHDSP_431G
DB3   7  11  dHDSP_431G
DC3   7   3  dHDSP_431G
DD3   7   4  dHDSP_431G
DE3   7   2  dHDSP_431G
DF3   7  15  dHDSP_431G
DG3   7   8  dHDSP_431G
DDP3  7   6  dHDSP_431G

.MODEL dHDSP_431G D
+ (
+     IS = 5.45751596E-12
+      N = 3.47011329
+     RS = 12.18613587
+     BV = 4.8
+    IBV = 100u
+ )

.ENDS HDSP_431G
