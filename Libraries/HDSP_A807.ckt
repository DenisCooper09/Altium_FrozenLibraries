*
* Diode Model Produced by Altium Ltd
* Date:  7-Apr-2004
*
* Manufacturer: Agilent
* Component Name: HDSP-A807
*
* Parameters derived from information available in data sheet.
*
*                 common-anode
*                 |  cathode-PLUS
*                 |  |  cathode-MINUS
*                 |  |  |  common-anode
*                 |  |  |  |  cathode-DP
*                 |  |  |  |  |  cathode-c
*                 |  |  |  |  |  |  cathode-b
*                 |  |  |  |  |  |  |
.SUBCKT HDSP_A807 1  2  3  6  7  8  9

DPLUS1  1  2 dHDSP_A807
DMINUS1 1  3 dHDSP_A807
DB1     1  9 dHDSP_A807
DC1     1  8 dHDSP_A807
DDP1    1  7 dHDSP_A807

DPLUS2  6  2 dHDSP_A807
DMINUS2 6  3 dHDSP_A807
DB2     6  9 dHDSP_A807
DC2     6  8 dHDSP_A807
DDP2    6  7 dHDSP_A807

.MODEL dHDSP_A807 D
+ (
+     IS = 6.64511693E-21
+      N = 1.66825537
+     RS = 20.13814139
+     BV = 30
+    IBV = 100u
+ )

.ENDS HDSP_A807
