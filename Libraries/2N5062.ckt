*2N5062 MCE 4-30-97
*Ref: Motorola Thyristor Device Data, Q2/95
*100V 1A pkg:TO-92B 1,2,3
.SUBCKT 2N5062   1 2 3
*    TERMINALS:  A G K
QP  6 4 1  POUT OFF
QN  4 6 5  NOUT OFF
RF  6 4    20MEG
RR  1 4    13.3MEG
RGK 6 5    240
RG  2 6    4.05
RK  3 5    0.15
DF  6 4    ZF
DR  1 4    ZR
DGK 6 5    ZGK
.MODEL ZF   D (IS=3.2E-16 IBV=1U BV=100)
.MODEL ZR   D (IS=3.2E-16 IBV=1U BV=100)
.MODEL ZGK  D (IS=3.2E-16 IBV=1U BV=5)
.MODEL POUT PNP (IS=320F BF=1 CJE=112P TF=51U)
.MODEL NOUT NPN (IS=320F BF=100 RC=0.6 CJE=558P CJC=112P TF=5.44U)
.ENDS
* Origin: Mcetriac.lib
