* .: 1 = Anode; .: 2 = Cathode; .: 3 = Anode
.SUBCKT 12ctq045 1 2 3
D1 1 2 12ctq045
D2 3 2 12ctq045

.MODEL 12ctq045 d
+(
+IS=5.30534e-09 RS=0.014271 N=0.891364 EG=0.6
+XTI=0.5 BV=45 IBV=0.0001 CJO=7.11199e-10
+VJ=1.5 M=0.484798 FC=0.5 TT=0
+KF=0 AF=1
+)

.ENDS 12ctq045
