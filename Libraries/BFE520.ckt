* BFE520 SPICE MODEL
* PHILIPS SEMICONDUCTORS
* Date : September 1995
*
* PACKAGE : SOT353B DIE MODEL : BFR520
* 1: COLLECTOR1; 2: BASE1; 3: EMITTER; 4: COLLECTOR2; 5: BASE2
.SUBCKT BFE520 1 2 3 4 5
Q1 6 7 8 8 BFR520
Q2 9 10 11 11 BFR520
* SOT353B parasitic model
               Lb1    2  7 .8n
               Lb2    5 10 .8n
               Le1    8 12 .6n
               Le2   11 12 .6n
               Lp1    1  6 .4n
               Lp2    4  9 .4n
               Lp3    3 12 .4n
               Cc1b1  1  2 36f
               Cc2b2  4  5 36f
               Cc1b2  1  5 2f
               Cc2b1  2  4 2f
               Cc1e   1  3 35f
               Cc2e   3  4 35f
               Cb1b2  2  5 3.5f
               Cc1c2  1  4 15f
               Cb1e   2  3 35f
*
* PHILIPS SEMICONDUCTORS                                     Version:   1.0
* Filename:   BFR520.PRM                                     Date: Feb 1992
*
.MODEL  BFR520   NPN
+(
+              IS = 1.01677E-015
+              BF = 2.20182E+002
+              NF = 1.00065E+000
+             VAF = 4.80619E+001
+             IKF = 5.10042E-001
+             ISE = 2.83095E-013
+              NE = 2.03568E+000
+              BR = 1.00714E+002
+              NR = 9.88109E-001
+             VAR = 1.69288E+000
+             IKR = 2.35262E-003
+             ISC = 2.44898E-017
+              NC = 1.02256E+000
+              RB = 1.00000E+001
+             IRB = 1.00000E-006
+             RBM = 1.00000E+001
+              RE = 7.75349E-001
+              RC = 2.21000E+000
+              EG = 1.11000E+000
+             XTI = 3.00000E+000
+             CJE = 1.24548E-012
+             VJE = 6.00000E-001
+             MJE = 2.58153E-001
+              TF = 8.61625E-012
+             XTF = 6.78866E+000
+             VTF = 1.41469E+000
+             ITF = 1.10365E-001
+             PTF = 4.50197E+001
+             CJC = 4.47646E-013
+             VJC = 1.89234E-001
+)
.ENDS
