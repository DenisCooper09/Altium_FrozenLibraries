*2N6238 MCE 4-30-97
*Ref: Motorola Thyristor Device Data, Q2/95
*100V 3A pkg:TO-126 2,3,1
.SUBCKT 2N6238   1 2 3
*    TERMINALS:  A G K
QP  6 4 1  POUT OFF
QN  4 6 5  NOUT OFF
RF  6 4    20MEG
RR  1 4    13.3MEG
RGK 6 5    300
RG  2 6    25
RK  3 5    29.3M
DF  6 4    ZF
DR  1 4    ZR
DGK 6 5    ZGK
.MODEL ZF   D (IS=1.04F IBV=1U BV=100)
.MODEL ZR   D (IS=1.04F IBV=1U BV=100)
.MODEL ZGK  D (IS=1.04F IBV=1U BV=6)
.MODEL POUT PNP (IS=1.04P BF=1 CJE=335P TF=51U)
.MODEL NOUT NPN (IS=1.04P BF=100 RC=0.117 CJE=1.68N CJC=335P TF=3.4U)
.ENDS
* Origin: Mcetriac.lib
