*MBR3045CT MCE 3/30/98
*Ref: IR Power Semiconductors Product Digest '94
*MCE 45V 30A 3us pkg:TO-3 1,3,2
.SUBCKT MBR3045CT 1 2 3
D1 1 2 DA
D2 3 2 DA
.MODEL DA D (IS=42.6N RS=1.4M N=1.7 BV=45 IBV=60M
+ CJO=1.23N VJ=0.75 M=0.333 TT=4.32U EG=.69 XTI=2)
.ENDS MBR3045CT
