*===========================================
* Q6006L5 MCE 3-7-97
* Ref: Teccor Electornics, Inc. General Catalog 95/96 pg. 20-21
*600V 6A pkg:TO-220 2,3,1
.SUBCKT Q6006L5  1  2  3
*     TERMINALS: MT2 G MT1
QN1  5 4 3  NOUT OFF
QN2 11 6 7  NOUT OFF
QP1 6 11 3  POUT OFF
QP2  4 5 7  POUT OFF
DF  4  5  DZ OFF
DR  6 11  DZ OFF
RF  4 6  12MEG
RT2 1 7  0.117
RH  7 6  125
RGP 8 3  19.8
RG  2 8  74.6
RS  8 4  159
DN  9 2  DIN OFF
RN  9 3  123
GNN  6 7 9 3 2.06M
GNP  4 5 9 3 989U
DP 2 10  DIP OFF
RP 10 3  893
GP  7 6 10 3 1.01M
.MODEL DIN  D (IS=32.1F)
.MODEL DIP  D (IS=32.1F N=1.5)
.MODEL DZ   D (IS=32.1F N=1.5 IBV=50U BV=600)
.MODEL POUT PNP (IS=32.1F BF=5 CJE=141P TF=76.5U)
.MODEL NOUT NPN (IS=32.1F BF=20 CJE=141P CJC=28.1P TF=5.1U)
.ENDS Q6006L5

* Origin: Mcetriac.lib
