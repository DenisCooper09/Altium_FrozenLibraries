*  HA-2544
*  COPYRIGHT (C) 1991 HARRIS CORPORATION
*  ALL RIGHTS RESERVED
*
* HA-2544 MACRO MODEL
* Rev: 4/19/91  D L Youngblood
*
* Connections:
*               Non-Inverting Input
*               |  Inverting Input
*               |  |  Positive Power Supply
*               |  |  |  Negative Power Supply
*               |  |  |  |  Output
*               |  |  |  |   |
.SUBCKT HA2544  6  7  9  10  8
.MODEL DP D  IS=1E-14  N=1.384E+01
.MODEL DN D  IS=9.7533E-15 N=1.384E+01
.MODEL DV D  IS=6.2773E-16  N=.1
.MODEL D1 D  IS=1E-14  N=1
.MODEL D2 D  IS=1E-14  N=5.0E-01
*
* Input Stage
*
VP 6 11 0
DP 11 1 DP
*
* The value of source "VIO" represents offset voltage
* and may be changed to simulate worst case if desired
*
VIO 7 12 -2.7757E-04
*
DN 12 1 DN
FA 7 0 VIO 1.0636E-02
I1 1 0 1.6994E-05
C1 1 0 1.4933E-15             IC=-7.3159
FP 4 0 VP  2.1354E+02
FN 0 4 VIO  2.1894E+02
GPP 0 4 9 13 4.9937E-07
GPN 0 4 14 10 2.6098E-07
RT 4 0 1
VPP 13 0 1.5E+01
RPP 13 0 1K
VPN 0 14 1.5E+01
RPN 0 14 1K
GC 0 4 1 0 7.1701E-11
ICO 0 4 5.2461E-10
*
* General Poles
*
EP1 17 0 4 0 1
RP1 17 18 2.1953E+01
CP1 18 0 1.0E-10
EP2 20 0 18 0 1
RP2 20 21 +7.2843
CP2 21 0 1.0E-10
EP3 22 0 21 0 1
RP3 22 23 +4.8433
CP3 23 0 1.0E-10
EP4 24 0 23 0 1
RP4 24 25 +2.2283
CP4 25 0 1.0E-10
EP5 26 0 25 0 1
RP5 26 27 +1.9908
CP5 27 0 1.0E-10
EP6 28 0 27 0 1
RP6 28 29 +1.6526
CP6 29 0 1.0E-10
*
* General Zero
*
GZ1 0 32 29 0 1.4448E-03
VZ01 32 33 0.0
HZ3 33 34 VZ01   6.9216E+02
LZ1 34 0 1.0E-6
*
* Gain / Output Stage
*
*For a Level 1 model, change node 32 on source "G2" to 4,
* add a capacitor from node 4 to node 0 of the value 1.69E-9,
* and comment out all general poles and zeros
*
G2 0 2 32 0 1
*
R2 2 0 1.7546E+05
CC 2 3 2.2E-11
GOL 3 0 2 0 7.8868E-02
RD 3 0 9.1695E+01
DH 3 5 DV
DL 40 3 DV
VH 9 5 3.7914
VL 40 10 1.9075
IH 9 0 1.0591E-02
IL 0 10 1.0608E-02
D1 3 43 D1
D2 43 3 D2
*EX1 43 0 POLY  2  3 0 3 8 0  1  -1.2895E-01
BEX1 43 0 V=1*v(3,0)-1.2895E-01*v(3,8)
RO 44 8 2.7421E+01
VIS 3 44 0
FI 0 45 VIS  1
DIP 45 46 DV
DIN 48 47 DV
VIP 46 48 0
VIN 47 45 0
RI 48 0 1
FIP 9 0 VIP  1
FIN 0 10 VIN  1
.ENDS HA2544
