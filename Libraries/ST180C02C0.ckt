*ST180C02C0 MCE 3/18/98
*Ref: IR Power Semiconductors Product Digest '94
*200V 660A pkg:TO-126 1,2,3
.SUBCKT ST180C02C0 1 2 3
*    TERMINALS:  A G K
QP  6 4 1  POUT OFF
QN  4 6 5  NOUT OFF
RF  6 4    4.85K
RR  1 4    3.23K
RGK 6 5    30
RG  2 6    42M
RK  3 5    394U
DF  6 4    ZF
DR  1 4    ZR
DGK 6 5    ZGK
.MODEL ZF   D (IS=264F IBV=8.25M BV=200)
.MODEL ZR   D (IS=264F IBV=8.25M BV=200)
.MODEL ZGK  D (IS=264F IBV=8.25M BV=5)
.MODEL POUT PNP (IS=264P BF=1 CJE=201P TF=232U)
.MODEL NOUT NPN (IS=264P BF=100 RC=1.58M CJE=1N CJC=201P TF=15.4U)
.ENDS

* Origin: Mcetriac.lib
