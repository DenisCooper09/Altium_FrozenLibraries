*/////////////////////////////////////////////////////////////////////////////////////
* LT1169  Dual Low Noise, Picoampere Bias Current, JFET-Input Operational Amplifier //
*/////////////////////////////////////////////////////////////////////////////////////
*
* connections:     non-inverting input
*                  |   inverting input
*                  |   |   positive power supply
*                  |   |   |   negative power supply
*                  |   |   |   |   output
*                  |   |   |   |   |
*                  |   |   |   |   |
.SUBCKT LT1169     3   2   7   4   6
* INPUT
RD1 4  80 6.0058E+02
RD2 4  90 6.0058E+02
J1  80 102 12 JM1
J2  90 103 12 JM2
CIN 2  3  1.5000E-12
RG1 2  102 2.0000E+00
RG2 3  103 2.0000E+00
C1  80 90 5.3139E-12
ISS 7  12 2.1000E-04
* INTERMEDIATE
GCM 0  8  12 0  2.9609E-08
GA  8  0  80 90 1.6650E-03
R2  8  0  1.0000E+05
C2  1  8  5.0000E-11
GB  1  0  8  0  7.6649E+02
RO2 1  0  3.5000E+01
* OUTPUT
RSO 1  6  1.0000E+00
ECL 18 0  1  6  1.6520E+01
GCL 0  8  20 0  1.0000E+00
RCL 20 0  1.0000E+03
D1  18 20 DM1
D2  20 18 DM1
*
D3A 131 70 DM3
D3B 13 131 DM3
GPL 0  8  70 7  1.0000E+00
VC  13 6  3.1324E+00
RPLA 7  70 1.0000E+04
RPLB 7  131 1.0000E+05
D4A 60 141 DM3
D4B 141 14  DM3
GNL 0  8  60 4  1.0000E+00
VE  6  14 3.1324E+00
RNLA 60 4  1.0000E+04
RNLB 141 4  1.0000E+05
*
IP  7  4  5.0900E-03
DSUB 4  7  DM2
* MODELS
.MODEL JM1 PJF (IS=5.2500E-12 BETA=6.6009E-03 VTO=-1.000000E+00)
.MODEL JM2 PJF (IS=2.7500E-12 BETA=6.6009E-03 VTO=-9.994000E-01)
.MODEL DM1  D   (IS=1.0000E-15)
.MODEL DM2  D   (IS=8.0000E-16 BV=4.8000E+01)
.MODEL DM3  D   (IS=1.0000E-16)
.MODEL DM4  D   (IS=1.0000E-09)
.ENDS LT1169
*
