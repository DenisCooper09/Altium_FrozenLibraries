*ZETEX  ZXM64P035G Mosfet Spice Subcircuit   Last revision 23/5/02
*NOTE: If required increase ABSTOL to resolve convergence problems.
*
* BC 5/1/2004: converted from pspice to spice
*
.SUBCKT ZXM64P035G 3 4 5
*----connections----D G S
*
M1 6 2 8 8 MOSMOD
M2 6 2 8 8 MOSMODS
RG 4 2 9
RIN 2 8 200E6
RD 3 6 RDSMOD 0.02
RS 8 5 RDSMOD 0.015
RL 3 5 35E6
C1 2 8 810E-12
C3 15 14 1050E-12
C4 16 8 1150E-12
D1 3 5 DMOD1
D2 3 17 DMOD2
S1 2 15 13 14 SMOD1a
S2 13 15 13 14 SMOD1b
S3 16 13 8 13 SMOD2a
S4 16 2 8 13 SMOD2b
Egs1 2 17 2 8 1
Egs2 13 8 2 8 1
Eds1 14 8 3 8 1
.MODEL MOSMOD PMOS VTO=-2.4 IS=1E-15 KP=8 CBD=512E-12 PB=1 LAMBDA=4.9E-3
.MODEL MOSMODS PMOS VTO=-2 IS=1E-15 KP=0.1 PB=1
.MODEL DMOD1 D IS=6E-13 RS=0.02 N=1.01 TT=1e-8
.MODEL DMOD2 D CJO=430e-12 IS=1e-30 N=10

* .MODEL SMOD1a VSWITCH RON=1e-2 ROFF=1e4  VON=-1.75 VOFF=2.75
.MODEL SMOD1a SW(RON=1e-2 ROFF=1e4 VH=-2.25 VT=0.5)

* .MODEL SMOD1b VSWITCH RON=1e-2 ROFF=1e4  VON=2.75 VOFF=-1.75
.MODEL SMOD1b SW(RON=1e-2 ROFF=1e4 VH=2.25 VT=0.5)

* .MODEL SMOD2a VSWITCH RON=1e-2 ROFF=1e4  VON=-1.5 VOFF=-3.5
.MODEL SMOD2a SW(RON=1e-2 ROFF=1e4 VH=1 VT=-2.5)

* .MODEL SMOD2b VSWITCH RON=1e-2 ROFF=1e4  VON=-3.5 VOFF=-1.5
.MODEL SMOD2b SW(RON=1e-2 ROFF=1e4 VH=-1 VT=-2.5)

* .MODEL RDSMOD RES (TC1=3E-3 TC2=1.5E-5)
.MODEL RDSMOD R (TC1=3E-3 TC2=1.5E-5)

.ENDS ZXM64P035G
*$
*                          (C)  2002 ZETEX PLC
*
*   The copyright in this model  and  the design embodied belong to
*   Zetex PLC ("Zetex"). It is supplied free of charge by Zetex for
*   the purpose  of research  and design  and may be used or copied
*   intact (including this notice) for that purpose only. All other
*   rights  are  reserved.  The model  is believed  accurate but no
*   condition or warranty as to its  merchantability or fitness for
*   purpose  is  given  and  no liability  in respect of any use is
*   accepted by Zetex PLC, its distributors or agents.
*
*
*   Zetex PLC, Fields New Road, Chadderton, Oldham OL9 8NP, UK
